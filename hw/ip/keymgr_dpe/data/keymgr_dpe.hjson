// Copyright lowRISC contributors (OpenTitan project).
// Licensed under the Apache License, Version 2.0, see LICENSE for details.
// SPDX-License-Identifier: Apache-2.0
{
  name:               "keymgr_dpe",
  human_name:         "Key Manager DPE",
  one_line_desc:      "Managing identities and root keys; shielding confidential assets from sw; Manage multiple DICE sessions in a DPE-compatible way",
  one_paragraph_desc: '''
  Key Manager DPE serves as the core hardware block for DPE. DPE stands for DICE Protection Environment.
  [DPE-version1.0-rev0.6]: https://trustedcomputinggroup.org/wp-content/uploads/TCG-DICE-Protection-Environment-Specification_14february2023-1.pdf
  '''
  // Unique comportable IP identifier defined under KNOWN_CIP_IDS in the regtool.
  cip_id:             "39",
  design_spec:        "../doc",
  dv_doc:             "../doc/dv",
  hw_checklist:       "../doc/checklist",
  sw_checklist:       "/sw/device/lib/dif/dif_keymgr_dpe",
  revisions: [
    {
      version:            "2.0.0",
      life_stage:         "L1",
      design_stage:       "D1",
      verification_stage: "V0",
      dif_stage:          "S0",
    }
  ]
  clocking: [
    {clock: "clk_i", reset: "rst_ni", primary: true},
    {clock: "clk_edn_i", reset: "rst_edn_ni"}
  ]
  bus_interfaces: [
    { protocol: "tlul", direction: "device" }
  ],
  interrupt_list: [
    { name: "op_done",   desc: "Operation complete" },
  ],
  alert_list: [
    { name: "recov_operation_err",
      desc: '''
        Alert for key manager operation errors.  These errors could have been caused by
        software'''
    },
    { name: "fatal_fault_err",
      desc: "Alert for key manager faults.  These errors cannot be caused by software",
    },

  ],

  inter_signal_list: [
    { struct:  "edn",
      type:    "req_rsp",
      name:    "edn",
      act:     "req",
      package: "edn_pkg",
    },
    { struct:  "hw_key_req",  // aes_key_req_t
      type:    "uni",
      name:    "aes_key",     // aes_key_o (req)
      act:     "req",
      package: "keymgr_dpe_pkg",  // Origin package (only needs for the requester)
    },
    { struct:  "hw_key_req",  // kmac_key_req_t
      type:    "uni",
      name:    "kmac_key",    // kmac_key_o (req)
      act:     "req",
      package: "keymgr_dpe_pkg",  // Origin package (only needs for the requester)
    },
    { struct:  "wide_hw_key_req",  // hmac_key_req_t
      type:    "uni",
      name:    "hmac_key",    // hmac_key_o (req)
      act:     "req",
      package: "keymgr_dpe_pkg",  // Origin package (only needs for the requester)
    },
    { struct:  "wide_hw_key_req",
      type:    "uni",
      name:    "otbn_key",
      act:     "req",
      package: "keymgr_dpe_pkg",
    },
    { struct:  "app",   // kmac_pkg::app_req_t, kmac_pkg::app_rsp_t
      type:    "req_rsp",
      name:    "kmac_app",   // kmac_app_o (req), kmac_app_i (rsp)
      act:     "req",
      package: "kmac_pkg",  // Origin package (only needs for the requester)
    },
    { struct:  "app",   // kmac_pkg::app_req_t, kmac_pkg::app_rsp_t
      type:    "req_rsp",
      name:    "otbn_app",   // otbn_app_o (req), otbn_app_i (rsp)
      act:     "req",
      package: "kmac_pkg",  // Origin package (only needs for the requester)
    },
    { struct:  "mubi4",
      type:    "uni",
      name:    "sensitive_key",
      act:     "req",
      package: "prim_mubi_pkg",
      default: "prim_mubi_pkg::MuBi4False",
    },
    { struct:  "keymgr_dpe_creator_root_key",
      type:    "uni",
      name:    "creator_root_key",
      act:     "rcv",
      package: "keymgr_dpe_pkg",
    },
    { struct:  "keymgr_dpe_creator_root_key",
      type:    "uni",
      name:    "secondary_root_key",
      act:     "rcv",
      package: "keymgr_dpe_pkg",
      default: "keymgr_dpe_pkg::KEYMGR_DPE_SECONDARY_ROOT_KEY_DEFAULT",
    },
    { struct:  "keymgr_dpe_creator_seed",
      type:    "uni",
      name:    "creator_seed",
      act:     "rcv",
      package: "keymgr_dpe_pkg",
    },
    { struct:  "keymgr_dpe_owner_seed",
      type:    "uni",
      name:    "owner_seed",
      act:     "rcv",
      package: "keymgr_dpe_pkg",
    },
    { struct:  "keymgr_dpe_device_id",
      type:    "uni",
      name:    "device_id",
      act:     "rcv",
      package: "keymgr_dpe_pkg",
    },
    { struct:  "keymgr_dpe_field_entropy",
      type:    "uni",
      name:    "field_entropy",
      act:     "rcv",
      package: "keymgr_dpe_pkg",
    },
    { struct:  "lc_tx",
      type:    "uni",
      name:    "lc_keymgr_en",
      act:     "rcv",
      package: "lc_ctrl_pkg",
      default: "lc_ctrl_pkg::On",
    },
    { struct:  "lc_keymgr_div",
      type:    "uni",
      name:    "lc_keymgr_div",
      act:     "rcv",
      package: "lc_ctrl_pkg",
    },
    { struct:  "keymgr_data"
      type:    "uni"
      name:    "rom_digest"
      act:     "rcv"
      package: "rom_ctrl_pkg"
      width:   "NumRomDigestInputs"
      default: "rom_ctrl_pkg::KEYMGR_DATA_DEFAULT"
    },
    { struct:  "logic"
      type:    "uni"
      name:    "kmac_en_masking"
      act:     "rcv"
    },
  ],

  param_list: [
    { name:      "KmacEnMasking",
      desc:      "Flag indicating with kmac masking is enabled",
      type:      "bit",
      default:   "1",
      local:     "false",
      expose:    "true",
    }
    // Random netlist constants
    { name:      "RndCnstLfsrSeed",
      desc:      "Compile-time random bits for initial LFSR seed",
      type:      "keymgr_dpe_pkg::lfsr_seed_t"
      randcount: "64",
      randtype:  "data",
    }
    { name:      "RndCnstLfsrPerm",
      desc:      "Compile-time random permutation for LFSR output",
      type:      "keymgr_dpe_pkg::lfsr_perm_t"
      randcount: "64",
      randtype:  "perm",
    },
    { name:      "RndCnstRandPerm",
      desc:      "Compile-time random permutation for entropy used in share overriding",
      type:      "keymgr_dpe_pkg::rand_perm_t"
      randcount: "32",
      randtype:  "perm",
    }
    { name:      "RndCnstRevisionSeed",
      desc:      "Compile-time random bits for revision seed",
      type:      "keymgr_dpe_pkg::seed_t"
      randcount: "256",
      randtype:  "data",
    },

    { name:      "RndCnstSoftOutputSeed",
      desc:      "Compile-time random bits for software generation seed",
      type:      "keymgr_dpe_pkg::seed_t"
      randcount: "256",
      randtype:  "data",
    },

    { name:      "RndCnstHardOutputSeed",
      desc:      "Compile-time random bits for hardware generation seed",
      type:      "keymgr_dpe_pkg::seed_t"
      randcount: "256",
      randtype:  "data",
    },

    { name:      "RndCnstAesSeed",
      desc:      "Compile-time random bits for generation seed when aes destination selected",
      type:      "keymgr_dpe_pkg::seed_t"
      randcount: "256",
      randtype:  "data",
    },

    { name:      "RndCnstKmacSeed",
      desc:      "Compile-time random bits for generation seed when kmac destination selected",
      type:      "keymgr_dpe_pkg::seed_t"
      randcount: "256",
      randtype:  "data",
    },

    { name:      "RndCnstOtbnSeed",
      desc:      "Compile-time random bits for generation seed when otbn destination selected",
      type:      "keymgr_dpe_pkg::seed_t"
      randcount: "256",
      randtype:  "data",
    },

    { name:      "RndCnstHmacSeed",
      desc:      "Compile-time random bits for generation seed when hmac destination selected",
      type:      "keymgr_dpe_pkg::seed_t"
      randcount: "256",
      randtype:  "data",
    },

    { name:      "RndCnstFieldEntropySeed",
      desc:      "Compile-time random bits as a field entropy alternative seed",
      type:      "keymgr_dpe_pkg::seed_t"
      randcount: "256",
      randtype:  "data",
    },

    { name:      "RndCnstNoneSeed",
      desc:      "Compile-time random bits for generation seed when no destination selected",
      type:      "keymgr_dpe_pkg::seed_t"
      randcount: "256",
      randtype:  "data",
    },
    { name: "NumSaltReg",
      desc: "Number of Registers for SW inputs (Salt)",
      type: "int",
      default: "8",
      local: "true"
    },
    { name: "NumSwBindingReg",
      desc: "Number of Registers for SW inputs (SW binding)",
      type: "int",
      default: "8",
      local: "true"
    },
    { name: "NumOutReg",
      desc: "Number of Registers for SW outputs",
      type: "int",
      default: "12",
      local: "true"
    },
    { name: "NumMaxHwSlot",
      desc: '''
        Number of maximum supported HW slots. If this value is changed then the
        bit width in SLOT_SRC_SEL / SLOT_DST_SEL in the
        "CONTROL_SHADOWED" register needs to be updated too.
      ''',
      type: "int",
      default: "8",
      local: "true"
    },
    { name: "NumInstHwSlot",
      desc: "Number of instantiated HW slots",
      type: "int",
      default: "4",
      expose:  "true"
    },
    { name: "NumBootStages",
      desc: "Number of available boot stages. Supported values are 2 and 4.",
      type: "int",
      default: "4",
      expose:  "true"
    },
    { name: "NumRomDigestInputs",
      desc: "Number of digest inputs from ROM_CTRL",
      type: "int",
      default: "1",
      expose:  "true"
    },
    { name:    "KdfEngineSel",
      desc:    '''
      Determines the possible KDF engines for the keymgr_dpe.
      Supported options are:
      - KdfEngineKmac: Uses exclusively `kmac` as kdf engine.
      - KdfEngineOtbn: Uses exclusively `otbn` as kdf engine.
      - KdfEngineBoth: The register !!KDF_ENGINE_SHADOWED selects if either the `kmac` or the `otbn` is used.
      ''',
      type:    "keymgr_dpe_pkg::kdf_engine_sel_e",
      default: "keymgr_dpe_pkg::KdfEngineKmac",
      expose:  "true"
    }
  ],

  features: [
    {
      name: "KEYMGR_DPE.SIDELOAD.KMAC",
      desc: '''Versioned key generation for KMAC. The key is only visible to hardware. This is
            tracked in a feature called KMAC.KEY.SIDELOAD, which is located inside the KMAC.
            '''
    }
    {
      name: "KEYMGR_DPE.SIDELOAD.AES",
      desc: '''Versioned key generation for AES. The key is only visible to hardware.
            '''
    }
    {
      name: "KEYMGR_DPE.SIDELOAD.OTBN",
      desc: '''Versioned key generation for OTBN. The key is only visible to hardware and OTBN
            code.
            '''
    }
    {
      name: "KEYMGR_DPE.SIDELOAD.HMAC",
      desc: '''Versioned key generation for HMAC. The key is only visible to hardware.
            '''
    }
    {
      name: "KEYMGR_DPE.GENERATE.OUTPUT",
      desc: '''Derivation of output keys with additional salt and version. Software provided
            salt and version values are used as inputs in the key derivation function along with
            the selected hw slot. The derived keys can be directed to software registers,
            or sideloaded to hardware security blocks.
            '''
    }
  ]

  countermeasures: [
    { name: "BUS.INTEGRITY",
      desc: "End-to-end bus integrity scheme."
    }
    { name: "CONFIG.SHADOW",
      desc: '''
        Various critical registers are shadowed: including operation !!CONTROL_SHADOWED,
        !!RESEED_INTERVAL_SHADOWED, !!KDF_ENGINE_SHADOWED and !!MAX_KEY_VER_SHADOWED.
      '''
    }
    { name: "OP.CONFIG.REGWEN",
      desc: '''
        Various control registers are locked during the duration of an operation:
        !!START, !!CONTROL_SHADOWED, !!SIDELOAD_CLEAR, !!SALT and !!KEY_VERSION.
      '''
    }
    { name: "RESEED.CONFIG.REGWEN",
      desc: '''
        Reseed interval is software lockable.
      '''
    }
    { name: "KDF_ENGINE.CONFIG.REGWEN",
      desc: '''
        Kdf engine selection is software lockable.
      '''
    }
    { name: "SW_BINDING.CONFIG.REGWEN",
      desc: '''
        Software binding is lockable by software in each stage. When keymgr_dpe successfully
        advances, the lock is released to allow the next stage the freedom to program.
      '''
    }
    { name: "MAX_KEY_VER.CONFIG.REGWEN",
      desc: '''
        Max key version is software lockable.
      '''
    }
    { name: "SLOT_POLICY.CONFIG.REGWEN",
      desc: '''
        Slot policy is software lockable.
      '''
    }
    { name: "LOAD_ROOT_KEY_LOCK.CTRL.LOCK_MUBI",
      desc: '''
        The !!LOAD_ROOT_KEY_LOCK register is multibit encoded. If this register is set
        then the `load root key` operation is disabled until the next reset. The operation
        is rejected with !!ERR_CODE.INVALID_OP when invoked.
      '''
    }
    { name: "LOAD_SECONDARY_ROOT_KEY_LOCK.CTRL.LOCK_MUBI",
      desc: '''
        The !!LOAD_SECONDARY_ROOT_KEY_LOCK register is multibit encoded. If this register is
        set then the `load secondary root key` operation is disabled until the next reset. The
        operation is rejected with !!ERR_CODE.INVALID_OP when invoked.
      '''
    }
    { name: "ENFORCE_SW_BINDING.CTRL.LOCK_MUBI",
      desc: '''
        Once !!ENFORCE_SW_BINDING is set, hardware requires CONTROL_SHADOWED.SW_BINDING_ONLY
        to be set on every subsequent advance operation from a parent whose boot stage
        consumes HW binding values. Otherwise an `invalid_op` error is raised, the operation
        is rejected, and the destination slot is not updated.
        !!ENFORCE_SW_BINDING is multibit encoded.
      '''
    }
    { name: "KDF_ENGINE.CTRL.MUBI",
      desc: '''
        Kdf engine selection register is multibit encoded.
      '''
    }
    { name: "METADATA.CONFIG.REGREN",
      desc: '''
        Once !!METADATA_READ_LOCK is set, !!METADATA_LOW and !!METADATA_HIGH read as zero until
        the next reset. !!METADATA_READ_LOCK is multibit encoded.
      '''
    }
    { name: "LC_CTRL.INTERSIG.MUBI",
      desc: '''
        Life cycle control signal is multibit.
      '''
    }
    { name: "CONSTANTS.CONSISTENCY",
      desc: '''
        Basic consistency checks (all 0's or all 1's) for keymgr_dpe diversification constants.
      '''
    }
    { name: "INTERSIG.CONSISTENCY",
      desc: '''
        Basic consistency checks (all 0's or all 1's) for otp diversification inputs.
      '''
    }
    { name: "HW.KEY.SW_NOACCESS",
      desc: '''
        Sideload keys are not directly accessible by software.
      '''
    }
    { name: "INTERNAL.KEY.SW_NOACCESS",
      desc: '''
        Internal keys are invisible to SW.
      '''
    }
    { name: "OUTPUT_KEYS.CTRL.REDUN",
      desc: '''
        Software and sideload keys are redundantly controlled. Each generate operation
        creates a valid and a data enable (software and sideload specific).

        In order for a key to be populated into the software register, both the software valid
        and the software data enable must be asserted.  The same is true for sideload.

        This makes it more difficult for an attack to fault a sideload key into the software key slot.
        An attacker would need to fault both the software valid and the software data enable.

        During a sideload operation, if an attacker manages to fault the valid but not the data enable,
        the software key is populated with random data.  If an attacker manages to fault the data enable but
        not the valid, then the software key retains its previous value.
      '''
    }
    { name: "CTRL.FSM.SPARSE",
      desc: '''
        Main control FSM is sparsely encoded.
      '''
    }
    { name: "DATA.FSM.SPARSE",
      desc: '''
        Control data FSM (for redundant data control) is sparsely encoded.
      '''
    }
    { name: "CTRL.FSM.LOCAL_ESC",
      desc: '''
        Main control FSM locally escalates based on any detected fault in keymgr_dpe.
        When a fault is detected (sync or async) the FSM transitions to invalid state to prevent
        further legal operations from executing.
      '''
    }
    { name: "CTRL.FSM.CONSISTENCY",
      desc: '''
        Main and operational FSM transitions are consistent with software commands.
      '''
    }
    { name: "CTRL.FSM.GLOBAL_ESC",
      desc: '''
        When the system globally escalates, the main control FSM also transitions to invalid state
        to prevent further legal operations from executing.
      '''
    }
    { name: "CTRL.CTR.REDUN",
      desc: '''
        Primary count is duplicated.
      '''
    }
    { name: "KMAC_IF.FSM.SPARSE",
      desc: '''
        kmac interface FSM is sparsely encoded.
      '''
    }
    { name: "KMAC_IF.CTR.REDUN",
      desc: '''
        Primary count uses cross count.
      '''
    }
    { name: "KMAC_IF_CMD.CTRL.CONSISTENCY",
      desc: '''
        One hot check for kmac interface commands.
        Also, command enable (adv_en, id_en, gen_en) is checked for consistency
        throughout the operation.
      '''
    }
    { name: "KMAC_IF_DONE.CTRL.CONSISTENCY",
      desc: '''
        Spurious kmac done check.
      '''
    }
    { name: "RESEED.CTR.REDUN",
      desc: '''
        Primary count is duplicated.
      '''
    }
    { name: "SIDE_LOAD_SEL.CTRL.CONSISTENCY",
      desc: '''
        Sideload key slot select is checked for consistency.
        When a key slot is valid when it should not be, an error is triggered.
        The reverse case is not checked, since an invalid key cannot be used
        anyways.
      '''
    }
    { name: "SIDELOAD_CTRL.FSM.SPARSE",
      desc: '''
        Sideload control FSM is sparsely encoded.
      '''
    }
    { name: "CTRL.KEY.INTEGRITY",
      desc: '''
        Internal secret key is protected with ECC.
      '''
    }
  ]

  regwidth: "32",
  registers: [
    { name: "CFG_REGWEN",
      desc: "Key manager configuration enable",
      swaccess: "ro",  // this lock is HW managed
      hwaccess: "hwo",
      hwext: "true",
      fields: [
        { bits: "0",
          name: "EN",
          resval: "1"
          desc: '''
            key manager configuration enable.
            When key manager operation is started (see CONTROL), registers protected by this EN are no longer
            modifiable until the operation completes.
          '''
        },
      ]
      // Don't let automated CSR tests write random values to this register, as it could lock
      // writing to other registers, which the automated tests are not aware of.
      tags: ["excl:CsrAllTests:CsrExclWrite"]
    },

    { name: "START",
      desc: "Key manager operation start",
      swaccess: "rw",
      hwaccess: "hrw",
      regwen: "CFG_REGWEN",
      fields: [
        { bits: "0",
          hwaccess: "hrw",
          name: "EN",
          desc: "Start key manager operations",
          resval: "0"
          enum: [
            { value: "1",
              name: "Valid state",
              desc: '''
                To trigger a start, this value must be programmed.  All other values are considered no operation start.
                '''
            },
          ]
          tags: [// bit self clears, handle in directed test
            "excl:CsrNonInitTests:CsrExclWrite"]
        }
      ]
    },

    { name: "CONTROL_SHADOWED",
      desc: "Key manager operation controls",
      regwen: "CFG_REGWEN",
      swaccess: "rw",
      hwaccess: "hro",
      shadowed: "true",
      update_err_alert: "recov_operation_err",
      storage_err_alert: "fatal_fault_err",
      fields: [
        { bits: "6:4",
          name: "OPERATION",
          desc: '''
            Key manager DPE operation selection.

            The remaining value (7) is invalid. Starting an operation with it
            makes it fail with `invalid_op` in every working state.
          ''',
          resval: "1",
          enum: [
            { value: "0",
              name: "Advance",
              desc: '''
                Advances a key manager DPE slot.
                '''
            },
            { value: "1",
              name: "Erase Slot",
              desc: '''
                Erases the secrets and resets the valid bit of the destination slot.
                '''
            },
            { value: "2",
              name: "Generate SW Output",
              desc: '''
                Generates a key manager output that is visible to software from the current state.
                '''
            },
            { value: "3",
              name: "Generate HW Output",
              desc: '''
                Generates a cryptographic key that is visible only to hardware crypto blocks.
                '''
            },
            { value: "4",
              name: "Disable",
              desc: '''
                Moves key manager DPE to disabled state.
                '''
            },
            {
              value: "5",
              name: "Load root key",
              desc: '''
                Loads the root key into the key manager. Can be disabled by !!LOAD_ROOT_KEY_LOCK if needed.
                '''
            },
            {
              value: "6",
              name: "Load secondary root key",
              desc: '''
                Loads the secondary root key into the key manager.
                Can be disabled by !!LOAD_SECONDARY_ROOT_KEY_LOCK if needed.
                '''
            },
          ],
        },

        { bits: "13:11",
          name: "DEST_SEL",
          desc: '''
            When the OPERATION field is programmed to generate output, this field selects
            the target cryptograhic use of the key.

            This field should be programmed for both HW / SW generation, as this helps diversify the output.
            The remaining values (5 to 7) are invalid and make a generate operation fail with `invalid_op`.
          ''',
          resval: "0"
          enum: [
            { value: "0",
              name: "None",
              desc: '''
                No target selected
                '''
            },
            { value: "1",
              name: "AES",
              desc: '''
                AES selected
                '''
            },
            { value: "2",
              name: "KMAC",
              desc: '''
                KMAC selected
                '''
            },
            { value: "3",
              name: "OTBN",
              desc: '''
                OTBN selected.  Note for OTBN hardware operations, the generated output is 512-bits.

                Generating a hardware 512-bit seed directly for OTBN sideload reduces some of the OTBN code burden for entropy expansion.
                When generating for software, this is not a concern.
                '''
            },
            { value: "4",
              name: "HMAC",
              desc: '''
                HMAC selected.  Note for HMAC hardware operations, the generated output is 512-bits.
                '''
            },
          ]
        },

        { bits: "16:14",
          name: "SLOT_SRC_SEL",
          resval: "0x0"
          desc: '''
            The source key slot to be used for the advance and generate operations.

            Only slots below `NumInstHwSlot` are instantiated.
            If this field selects a slot at or above `NumInstHwSlot`, an advance or generate operation
            is rejected with !!ERR_CODE.INVALID_OP and no slot is modified.
          '''
        },

        { bits: "20:18",
          name: "SLOT_DST_SEL",
          resval: "0x0"
          desc: '''
            The destination key slot to be used for the advance, erase, load root key and load secondary root key operations.

            Only slots below `NumInstHwSlot` are instantiated.
            If this field selects a slot at or above `NumInstHwSlot`, an advance, erase,
            load root key or load secondary root key operation is rejected with !!ERR_CODE.INVALID_OP
            and no slot is modified.
          '''
        },

        {
          bits: "22"
          name: "SW_BINDING_ONLY"
          resval: "0"
          desc: '''
            Only apply software binding as a message input to the advance operation.

            See !!ENFORCE_SW_BINDING to make this mandatory for all advance calls until the next reset.
          '''
        },

        { bits: "26:24",
          name: "SLOT_SRC_SEL_SHADOWED",
          resval: "0x0"
          desc: '''
            Must be programmed to the same value as `SLOT_SRC_SEL`.
            A mismatch will reject any operation.
          '''
        },

        { bits: "30:28",
          name: "SLOT_DST_SEL_SHADOWED",
          resval: "0x0"
          desc: '''
            Must be programmed to the same value as `SLOT_DST_SEL`.
            A mismatch will reject any operation.
          '''
        }
      ],
    },

    { name: "SIDELOAD_CLEAR",
      desc: "sideload key slots clear"
      swaccess: "rw",
      hwaccess: "hro",
      regwen: "CFG_REGWEN",
      fields: [
        { bits: "2:0",
          name: "VAL",
          resval: "0"
          desc: '''
            Depending on the value programmed, a different sideload key slot is cleared.
            If the value programmed is not one of the enumerated values below, ALL sideload
            key slots are continuously cleared. In order to stop continuous clearing, SW should
            toggle the clear bit again (i.e. disable continuous clearing).
          ''',
          enum: [
            { value: "0",
              name: "None",
              desc: '''
                No sideload keys cleared.
                '''
            },
            { value: "1",
              name: "AES",
              desc: '''
                The AES sideload key is continuously cleared with entropy.
                '''
            },
            { value: "2",
              name: "KMAC",
              desc: '''
                The KMAC sideload key is continuously cleared with entropy.
                '''
            },
            { value: "3",
              name: "OTBN",
              desc: '''
                The OTBN sideload key is continuously cleared with entropy.
                '''
            },
            { value: "4",
              name: "HMAC",
              desc: '''
                The HMAC sideload key is continuously cleared with entropy.
                '''
            },
          ]

        },
      ]
    },

    { name: "RESEED_INTERVAL_REGWEN",
      desc: "regwen for reseed interval",
      swaccess: "rw0c",
      hwaccess: "none",
      fields: [
        { bits: "0",
          name: "EN",
          resval: "1"
          desc: '''
            Configuration enable for reseed interval.
          '''
        },
      ]
      // Don't let automated CSR tests write random values to this register, as it could lock
      // writing to other registers, which the automated tests are not aware of.
      tags: ["excl:CsrAllTests:CsrExclWrite"]
    },

    { name: "RESEED_INTERVAL_SHADOWED",
      desc: "Reseed interval for key manager entropy reseed",
      shadowed: "true",
      update_err_alert: "recov_operation_err",
      storage_err_alert: "fatal_fault_err",
      regwen: "RESEED_INTERVAL_REGWEN",
      swaccess: "rw",
      hwaccess: "hro",
      fields: [
        { bits: "15:0",
          name: "VAL",
          resval: "0x100"
          desc: '''
            Number of internal PRNG updates before a reseed is requested.
          '''
        },
      ]
    },

    { name: "KDF_ENGINE_REGWEN",
      desc: "Register write enable for KDF_ENGINE",
      swaccess: "rw0c",
      hwaccess: "none",
      fields: [
        { bits: "0",
          name: "EN",
          resval: "1"
          desc: '''
            Configuration enable for KDF_ENGINE.
          '''
        },
      ]
      // Don't let automated CSR tests write random values to this register, as it could lock
      // writing to other registers, which the automated tests are not aware of.
      tags: ["excl:CsrAllTests:CsrExclWrite"]
    },

    { name: "KDF_ENGINE_SHADOWED",
      desc: "Selects the engine used to perform key derivation if KdfEngineSel equals `KdfEngineBoth`, otherwise ignored.",
      shadowed: "true",
      update_err_alert: "recov_operation_err",
      storage_err_alert: "fatal_fault_err",
      regwen: "KDF_ENGINE_REGWEN",
      swaccess: "rw",
      hwaccess: "hro",
      fields: [
        { bits: "3:0",
          name: "SEL",
          mubi: true,
          resval: false
          desc: '''
            Selects the engine used for key derivation.

            kMultiBitBool4True selects OTBN using HKDF.
            kMultiBitBool4False selects KMAC.
          '''
        },
      ]
    },

    { name: "SLOT_POLICY_REGWEN",
      desc: "Register write enable for SLOT_POLICY",
      swaccess: "rw0c",
      hwaccess: "hrw",
      hwext: "true",
      hwqe: "true",
      fields: [
        { bits: "0",
          name: "EN",
          resval: "1"
          desc: '''
            Locks SLOT_POLICY register.

            After a successful advance operation, this register is unlocked again.
          '''
        },
      ]
      // Don't let automated CSR tests write random values to this register, as it could lock
      // writing to other registers, which the automated tests are not aware of.
      tags: ["excl:CsrAllTests:CsrExclWrite"]
    },

    { name: "SLOT_POLICY",
      desc: "Policy bits for the child DPE context",
      swaccess: "rw",
      hwaccess: "hro",
      regwen: "SLOT_POLICY_REGWEN",
      fields: [
        { bits: "0",
          name: "ALLOW_CHILD",
          resval: "0"
          desc: '''
            Set whether this context allows derivation of further children.
          '''
        },
        { bits: "1",
          name: "EXPORTABLE",
          resval: "0"
          desc: '''
            Set whether the key for the target slot is exportable.
          '''
        },
        { bits: "2",
          name: "RETAIN_PARENT",
          resval: "0"
          desc: '''
            Set whether further advance operations force erasure of the slot.
          '''
        },
        { bits: "3",
          name: "ALLOW_KEYGEN",
          resval: "0"
          desc: '''
            Set whether this context can be used to generate keys.
            This applies to both software and sideload key generation.
          '''
        },
      ]
    },

    { name: "SW_BINDING_REGWEN",
      desc: "Register write enable for SOFTWARE_BINDING",
      swaccess: "rw0c",
      hwaccess: "hrw",
      hwext: "true",
      hwqe: "true",
      fields: [
        { bits: "0",
          name: "EN",
          resval: "1"
          desc: '''
            Software binding register write enable.
            This is locked by software and unlocked by hardware upon a successful advance call.

            Software binding resets to 1, and its value cannot be altered by software until advancement to Init state.
          '''
        },
      ]
      // Don't let automated CSR tests write random values to this register, as it could lock
      // writing to other registers, which the automated tests are not aware of.
      tags: ["excl:CsrAllTests:CsrExclWrite"]
    },

    { multireg: {
        cname: "KEYMGR",
        name: "SW_BINDING",
        regwen: "SW_BINDING_REGWEN",
        desc: '''
          Software binding input of the key manager.
          This register is lockable and shared between key manager stages.
          This binding value is not considered secret, however its integrity is very important.

          The software binding is locked by software and unlocked by hardware upon a successful advance operation.
        ''',
        count: "NumSwBindingReg",
        swaccess: "rw",
        hwaccess: "hro",
        fields: [
            { bits: "31:0",
              name: "VAL",
              desc: '''
                Software binding value
              ''',
              resval: "0"
            },
        ],
      },
    },

    { multireg: {
        cname: "KEYMGR",
        name: "SALT",
        regwen: "CFG_REGWEN",
        desc: '''
          Salt value used as part of output generation.
        ''',
        count: "NumSaltReg",
        swaccess: "rw",
        hwaccess: "hro",
        fields: [
            { bits: "31:0",
              name: "VAL",
              desc: '''
                Salt value
              ''',
              resval: "0"
            },
        ],
      },
    },

    { name: "KEY_VERSION",
      regwen: "CFG_REGWEN",
      desc: "Version used as part of output generation.",
      swaccess: "rw",
      hwaccess: "hro",
      fields: [
        { bits: "31:0",
          name: "VAL",
          desc: '''
            Key version
          ''',
          resval: "0"
        },
      ],
    },

    { name: "MAX_KEY_VER_REGWEN",
      desc: "Register write enable for MAX_KEY_VERSION",
      swaccess: "rw0c",
      hwaccess: "hrw",
      hwext: "true",
      hwqe: "true",
      fields: [
        { bits: "0",
          name: "EN",
          resval: "1"
          desc: '''
            MAX_KEY_VERSION configure enable.
          '''
        },
      ]
      // Don't let automated CSR tests write random values to this register, as it could lock
      // writing to other registers, which the automated tests are not aware of.
      tags: ["excl:CsrAllTests:CsrExclWrite"]
    },

    { name: "MAX_KEY_VER_SHADOWED",
      desc: "Max key version",
      swaccess: "rw",
      hwaccess: "hro",
      shadowed: "true",
      update_err_alert: "recov_operation_err",
      storage_err_alert: "fatal_fault_err",
      regwen: "MAX_KEY_VER_REGWEN",
      fields: [
        { bits: "31:0",
          name: "VAL",
          resval: "0x0"
          desc: '''
            Max key version.

            Any key version up to the value specified in this register is valid.
          '''
        },
      ]
    },

    { multireg: {
        cname: "KEYMGR",
        name: "SW_SHARE0_OUTPUT",
        desc: '''
          Key manager software output.

          When a software output operation is selected, the results of the operation are placed
          here.
        ''',
        count: "NumOutReg",
        swaccess: "rc",
        hwaccess: "hwo",
        fields: [
            { bits: "31:0",
              name: "VAL",
              desc: '''
                Software output value
              ''',
              resval: "0"
            },
        ],
        tags: [// HW-update reg
               // When a fault happens (e.g. when we test TL integrity error), this CSR will be
               // wiped with random value.
               "excl:CsrNonInitTests:CsrExclCheck"]
      },
    },

    { multireg: {
        cname: "KEYMGR",
        name: "SW_SHARE1_OUTPUT",
        desc: '''
          Key manager software output.

          When a software output operation is selected, the results of the operation are placed
          here.
        ''',
        count: "NumOutReg",
        swaccess: "rc",
        hwaccess: "hwo",
        fields: [
            { bits: "31:0",
              name: "VAL",
              desc: '''
                Software output value
              ''',
              resval: "0"
            },
        ],
        tags: [// HW-update reg
               // When a fault happens (e.g. when we test TL integrity error), this CSR will be
               // wiped with random value.
               "excl:CsrNonInitTests:CsrExclCheck"]
      },
    },

    { name: "WORKING_STATE",
      desc: '''
        Key manager working state.

        This is a readout of the current key manager working state.
      ''',
      swaccess: "ro",
      hwaccess: "hwo",
      fields: [
        { bits: "1:0",
          name: "STATE",
          resval: "0x0"
          desc: "Key manager control state",
          enum: [
            { value: "0",
              name: "Reset",
              desc: '''
                Key manager control is still in reset.  Please wait for initialization complete
                before issuing operations
              '''
            },
            { value: "1",
              name: "Available",
              desc: '''
                Key manager control has finished latching OTP root key and will now accept
                software commands.
              '''
            },
            { value: "2",
              name: "Disabled",
              desc: '''
                Key manager currently disabled. Please reset the key manager.
                Sideload keys are still valid.
              '''
            },
            { value: "3",
              name: "Invalid",
              desc: '''
                Key manager currently invalid. Please reset the key manager.
                Sideload keys are no longer valid.
              '''
            },
          ]
        }
      ]
    },

    { name: "OP_STATUS",
      desc: '''
        Key manager status.

        Hardware sets the status based on software initiated operations.
        This register must be explicitly cleared by software.
        Software clears by writing back whatever it reads.
      ''',
      swaccess: "rw1c",
      hwaccess: "hwo",
      fields: [
        { bits: "1:0",
          name: "STATUS",
          resval: "0x0"
          desc: "Operation status.",
          enum: [
            { value: "0",
              name: "Idle",
              desc: '''
                Key manager is idle
                '''
            },
            { value: "1",
              name: "WIP",
              desc: '''
                Work in progress.
                A key manager operation has been started and is ongoing.
                '''
            },
            { value: "2",
              name: "DONE_SUCCESS",
              desc: '''
                Operation finished without errors.
                '''
            },
            { value: "3",
              name: "DONE_ERROR",
              desc: '''
                Operation finished with errors, please see ERR_CODE register.
                '''
            },
          ]
        },
      ]
    },

    { multireg: {
        cname: "KEYMGR",
        name: "METADATA_LOW",
        desc: '''
          Read metadata (low word) for each HW slot.

          Only the first `NumInstHwSlot` slots are instantiated.
          Entries at index `NumInstHwSlot` and above always read as 0.
          All entries read as 0 once !!METADATA_READ_LOCK is set.
          Together with !!METADATA_HIGH, this register lets software inspect the non-secret
          metadata of the DPE context.
        ''',
        count: "NumMaxHwSlot",
        swaccess: "ro",
        hwaccess: "hwo",
        hwext: "true",
        fields: [
            { bits: "31:0",
              name: "MAX_KEY_VERSION",
              desc: '''
                Maximum key version allowed for key derived from this DPE context.
              ''',
              resval: "0"
            },
        ],
      },
    },

    { multireg: {
        cname: "KEYMGR",
        name: "METADATA_HIGH",
        desc: '''
          Read metadata (high word) for each HW slot.

          Only the first `NumInstHwSlot` slots are instantiated.
          Entries at index `NumInstHwSlot` and above always read as 0.
          All entries read as 0 once !!METADATA_READ_LOCK is set.
          Together with !!METADATA_LOW, this register lets software inspect the non-secret
          metadata of the DPE context.
        ''',
        count: "NumMaxHwSlot",
        swaccess: "ro",
        hwaccess: "hwo",
        hwext: "true",
        fields: [
            { bits: "0",
              name: "VALID",
              desc: '''
                Set if the DPE context held in this slot is valid.
              ''',
              resval: "0"
            },
            { bits: "3:1",
              name: "BOOT_STAGE",
              desc: '''
                Boot stage associated with the DPE context held in this slot.

                | Value | Boot stage          |
                |:-----:|:--------------------|
                | 0     | BootStageCreator    |
                | 1     | BootStageCreatorInt |
                | 2     | BootStageOwnerInt   |
                | 3     | BootStageOwner      |
                | 4     | BootStageRuntime    |

                In the two-stage configuration (`NumBootStages` equals 2), the values 1 and 2
                are not used.

                The naming indicates the next bootstage after a successful key derivation
                e.g. boot stage 1 means the context is the _CreatorRootKey_ and will be
                derived into the _CreatorIntKey_.
              ''',
              resval: "0"
            },
            { bits: "4",
              name: "ALLOW_CHILD_POLICY",
              resval: "0"
              desc: '''
                Read the `allow_child` policy applied to the DPE context in this slot.
              '''
            },
            { bits: "5",
              name: "EXPORTABLE_POLICY",
              resval: "0"
              desc: '''
                Read the `exportable` policy applied to the DPE context in this slot.
              '''
            },
            { bits: "6",
              name: "RETAIN_PARENT_POLICY",
              resval: "0"
              desc: '''
                Read the `retain_parent` policy applied to the DPE context in this slot.
              '''
            },
            { bits: "7",
              name: "ALLOW_KEYGEN_POLICY",
              resval: "0"
              desc: '''
                Read the `allow_keygen` policy applied to the DPE context in this slot.
              '''
            },
        ],
      },
    },

    { name: "ERR_CODE",
      desc: '''
        Key manager error code.
        This register must be explicitly cleared by software.

        This register represents both synchronous and asynchronous recoverable
        errors.

        Synchronous errors refer to those that only happen when a keymgr operation is
        invoked, while asynchronous refers to errors that can happen at any time.
      ''',
      swaccess: "rw1c",
      hwaccess: "hwo",
      fields: [
        { bits: "0",
          name: "INVALID_OP",
          resval: "0x0"
          desc: "Invalid operation issued to key manager, synchronous error",
        },
        { bits: "1",
          name: "INVALID_KMAC_INPUT",
          resval: "0x0"
          desc: "Invalid data issued to kmac interface, synchronous error",
        },
        { bits: "2",
          name: "INVALID_SHADOW_UPDATE",
          resval: "0x0"
          desc: "An error observed during shadow register updates, asynchronous error",
        },
      ]
    },

    { name: "FAULT_STATUS",
      desc: '''
        This register represents both synchronous and asynchronous fatal faults.

        Synchronous faults refer to those that only happen when a keymgr operation is
        invoked, while asynchronous refers to faults that can happen at any time.

      ''',
      swaccess: "ro",
      hwaccess: "hrw",
      fields: [
        { bits: "0",
          name: "CMD",
          resval: "0x0"
          desc: "A non-onehot command was seen in kmac, asynchronous fault.",
        },
        { bits: "1",
          name: "KMAC_FSM",
          resval: "0x0"
          desc: "The kmac transfer interface FSM is in an invalid state, asynchronous fault.",
        },
        { bits: "2",
          name: "KMAC_DONE",
          resval: "0x0"
          desc: "The kmac transfer interface encountered an unexpected done, asynchronous fault.",
        },
        { bits: "3",
          name: "KMAC_OP",
          resval: "0x0"
          desc: "KMAC reported an error during keymgr usage, this should never happen - synchronous fault.",
        },
        { bits: "4",
          name: "KMAC_OUT",
          resval: "0x0"
          desc: "KMAC data returned as all 0's or all 1's - synchronous fault",
        },
        { bits: "5",
          name: "REGFILE_INTG",
          resval: "0x0"
          desc: "Register file integrity error, asynchronous fault",
        },
        { bits: "6",
          name: "SHADOW",
          resval: "0x0"
          desc: "Shadow copy storage error, asynchronous fault",
        },
        { bits: "7",
          name: "CTRL_FSM_INTG",
          resval: "0x0"
          desc: "Control FSM integrity error, asynchronous fault",
        },
        { bits: "8",
          name: "CTRL_FSM_CHK",
          resval: "0x0"
          desc: "Control FSM cross check error, asynchronous fault",
        },
        { bits: "9",
          name: "CTRL_FSM_CNT",
          resval: "0x0"
          desc: "Control FSM counter integrity error, asynchronous fault",
        },
        { bits: "10",
          name: "RESEED_CNT",
          resval: "0x0"
          desc: "Reseed counter integrity error, asynchronous fault",
        },
        { bits: "11",
          name: "SIDE_CTRL_FSM",
          resval: "0x0"
          desc: "Sideload control FSM integrity error, asynchronous fault",
        },
        { bits: "12",
          name: "SIDE_CTRL_SEL",
          resval: "0x0"
          desc: "Sideload control key select error, synchronous fault",
        },
        { bits: "13",
          name: "KEY_ECC",
          resval: "0x0"
          desc: "Secret key ecc error, asynchronous fault",
        },
      ]
    },

    { name: "DEBUG",
      desc: '''
        The register holds some debug information that may be convenient if keymgr
        misbehaves.
      ''',
      swaccess: "rw0c",
      hwaccess: "hwo",
      fields: [
        { bits: "0",
          name: "INVALID_CREATOR_SEED",
          resval: "0x0"
          desc: "Creator seed was not marked valid or failed input checks during operation",
        },
        { bits: "1",
          name: "INVALID_OWNER_SEED",
          resval: "0x0"
          desc: "Owner seed was not marked valid or failed input checks during operation",
        },
        { bits: "2",
          name: "INVALID_DEV_ID",
          resval: "0x0"
          desc: "Device ID failed input checks during operation",
        },
        { bits: "3",
          name: "INVALID_HEALTH_STATE",
          resval: "0x0"
          desc: "Health state failed input checks during operation",
        },
        { bits: "4",
          name: "INVALID_KEY_VERSION",
          resval: "0x0"
          desc: "Key version failed input checks during operation",
        },
        { bits: "5",
          name: "INVALID_KEY",
          resval: "0x0"
          desc: "Key fed to kmac failed input checks during operation",
        },
        { bits: "6",
          name: "INVALID_DIGEST",
          resval: "0x0"
          desc: "ROM digest failed input checks during operation",
        },
        { bits: "7",
          name: "INVALID_ROOT_KEY",
          resval: "0x0"
          desc: "OTP root key was invalid during the first advance or during a `load root key` operation",
        },
        { bits: "8",
          name: "INACTIVE_LC_EN",
          resval: "0x0"
          desc: "Enable signal from LC ctrl is deactivated",
        },
        { bits: "9",
          name: "INVALID_SECONDARY_ROOT_KEY",
          resval: "0x0"
          desc: "Secondary root key was invalid during a `load secondary root key` operation",
        },
        { bits: "10",
          name: "INVALID_FIELD_ENTROPY",
          resval: "0x0"
          desc: '''
            Field entropy (or, if not marked valid, the netlist constant substitute) failed input checks.
            Only evaluated when `NumBootStages` equals 4, as the field entropy is not consumed otherwise.
          ''',
        },
      ]
    },

    { name: "LOAD_ROOT_KEY_LOCK",
      desc: "Register lock for the `load root key` operation, see !!CONTROL_SHADOWED.OPERATION.",
      swaccess: "rw1s",
      hwaccess: "hro",
      fields: [
        { bits: "3:0",
          name: "LOCK",
          mubi: true,
          resval: false
          desc: '''
            Write `kMultiBitBool4True` to disable the `load root key` operation until the next reset.
            However, all encodings except `kMultiBitBool4False` will be treated as locked.
          '''
        },
      ]
      // Don't let automated CSR tests write random values to this register, as it could lock
      // writing to other registers, which the automated tests are not aware of.
      tags: ["excl:CsrAllTests:CsrExclWrite"]
    },

    { name: "LOAD_SECONDARY_ROOT_KEY_LOCK",
      desc: "Register lock for the `load secondary root key` operation, see !!CONTROL_SHADOWED.OPERATION.",
      swaccess: "rw1s",
      hwaccess: "hro",
      fields: [
        { bits: "3:0",
          name: "LOCK",
          mubi: true,
          resval: false
          desc: '''
            Write `kMultiBitBool4True` to disable the `load secondary root key` operation until the next reset.
            However, all encodings except `kMultiBitBool4False` will be treated as locked.
          '''
        },
      ]
      // Don't let automated CSR tests write random values to this register, as it could lock
      // writing to other registers, which the automated tests are not aware of.
      tags: ["excl:CsrAllTests:CsrExclWrite"]
    },

    { name: "ENFORCE_SW_BINDING",
      desc: "Enforce the software binding value as the only advance input message until the next reset",
      swaccess: "rw1s",
      hwaccess: "hro",
      fields: [
        { bits: "3:0",
          name: "ENFORCE",
          mubi: true,
          resval: false
          desc: '''
          Enforce using only sw binding value for context derivation.

          Once set no hw binding value can be consumed until the next reset.
          An advance operation from a parent whose boot stage consumes hw binding values
          (`boot_stage` 0 to 3, i.e. Creator, CreatorInt, OwnerInt or Owner) without
          `CONTROL_SHADOWED.SW_BINDING_ONLY` set will fail with an `invalid_op` error without
          updating the destination slot.
          Advance operations from later boot stages are not affected.

          Every encoding except `kMultiBitBool4False` will be treated as locked.
          '''
        },
      ]
      // Don't let automated CSR tests write random values to this register, as it could lock
      // writing to other registers, which the automated tests are not aware of.
      tags: ["excl:CsrAllTests:CsrExclWrite"]
    },

    { name: "METADATA_READ_LOCK",
      desc: "Disable software read access to the slot metadata until the next reset",
      swaccess: "rw1s",
      hwaccess: "hro",
      fields: [
        { bits: "3:0",
          name: "LOCK",
          mubi: true,
          resval: false
          desc: '''
            Write `kMultiBitBool4True` to disable reading !!METADATA_LOW and !!METADATA_HIGH
            until the next reset. Once locked, both registers read as zero.

            Every encoding except `kMultiBitBool4False` will be treated as locked.
          '''
        },
      ]
      // Don't let automated CSR tests write random values to this register, as it would lock
      // reading of the metadata registers, which the automated tests are not aware of.
      tags: ["excl:CsrAllTests:CsrExclWrite"]
    },

  ],
}
