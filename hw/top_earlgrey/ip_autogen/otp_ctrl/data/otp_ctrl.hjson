// Copyright lowRISC contributors (OpenTitan project).
// Licensed under the Apache License, Version 2.0, see LICENSE for details.
// SPDX-License-Identifier: Apache-2.0
//
// HJSON with partition metadata.
//
{
  name:               "otp_ctrl",
  human_name:         "One-Time Programmable Memory Controller",
  one_line_desc:      "Interfaces integrated one-time programmable memory, supports scrambling, integrity and secure wipe",
  one_paragraph_desc: '''
  One-Time Programmable (OTP) Memory Controller provides an open source abstraction interface for software and other hardware components such as Life Cycle Controller and Key Manager to interact with an integrated, closed source, proprietary OTP memory.
  On top of defensive features provided by the proprietary OTP memory to deter side-channel analysis (SCA), fault injection (FI) attacks, and visual and electrical probing, the open source OTP controller features high-level logical security protection such as integrity checks and scrambling, as well as software isolation for when OTP contents are readable and programmable.
  It features multiple individually-lockable logical partitions, periodic / persistent checking of OTP values, and a separate partition and interface for Life Cycle Controller.
  '''
  // Unique comportable IP identifier defined under KNOWN_CIP_IDS in the regtool.
  cip_id:             "16",
  design_spec:        "../doc",
  dv_doc:             "../doc/dv",
  hw_checklist:       "../doc/checklist",
  sw_checklist:       "/sw/device/lib/dif/dif_otp_ctrl",
  revisions: [
    {
      version:            "0.1.0",
      life_stage:         "L1",
      design_stage:       "D2",
      verification_stage: "V2",
      dif_stage:          "S1",
      commit_id:          "127b109e2fab9336e830158abe449a3922544ded",
      notes:              "",
    }
    {
      version:            "1.0.0",
      life_stage:         "L1",
      design_stage:       "D3",
      verification_stage: "V2S",
      dif_stage:          "S2",
      notes:              "",
    }
    {
      version:            "2.0.0",
      life_stage:         "L1",
      design_stage:       "D3",
      verification_stage: "V2S",
      dif_stage:          "S2",
      commit_id:          "aaf0970acc8d5c466308a3a856e9433d85636c95",
      notes:              "",
    }
    {
      version:            "3.0.0",
      life_stage:         "L1",
      design_stage:       "D1",
      verification_stage: "V0",
      dif_stage:          "S1",
      notes:              "",
    }
  ]
  clocking: [
    {clock: "clk_i", reset: "rst_ni", primary: true},
    {clock: "clk_edn_i", reset: "rst_edn_ni"}
  ]
  bus_interfaces: [
    { protocol: "tlul", direction: "device", name: "core" }
  ],

  ///////////////////////////
  // Interrupts and Alerts //
  ///////////////////////////

  interrupt_list: [
    { name: "otp_operation_done",
      desc: "A direct access command or digest calculation operation has completed."
    }
    { name: "otp_error",
      desc: "An error has occurred in the OTP controller. Check the !!ERR_CODE register to get more information."
    }
  ],

  alert_list: [
    { name: "fatal_macro_error",
      desc: "This alert triggers if hardware detects an uncorrectable error during an OTP transaction, for example an uncorrectable ECC error in the OTP array.",
    }
    { name: "fatal_check_error",
      desc: "This alert triggers if any of the background checks fails. This includes the digest checks and concurrent ECC checks in the buffer registers.",
    }
    { name: "fatal_bus_integ_error",
      desc: "This fatal alert is triggered when a fatal TL-UL bus integrity fault is detected."
    }
    { name: "fatal_prim_otp_alert",
      desc: "Fatal alert triggered inside the OTP primitive, including fatal TL-UL bus integrity faults of the test interface."
    }
    { name: "recov_prim_otp_alert",
      desc: "Recoverable alert triggered inside the OTP primitive."
    }
  ],

  ////////////////
  // Parameters //
  ////////////////
  param_list: [
    // Random netlist constants
    { name:      "RndCnstLfsrSeed",
      desc:      "Compile-time random bits for initial LFSR seed",
      type:      "otp_ctrl_top_specific_pkg::lfsr_seed_t"
      randcount: "40",
      randtype:  "data", // randomize randcount databits
    }
    { name:      "RndCnstLfsrPerm",
      desc:      "Compile-time random permutation for LFSR output",
      type:      "otp_ctrl_top_specific_pkg::lfsr_perm_t"
      randcount: "40",
      randtype:  "perm", // random permutation for randcount elements
    }
    { name:      "RndCnstScrmblKeyInit",
      desc:      "Compile-time random permutation for scrambling key/nonce register reset value",
      type:      "otp_ctrl_top_specific_pkg::scrmbl_key_init_t"
      randcount: "256",
      randtype:  "data", // random permutation for randcount elements
    }
    // Scrambling Keys
    { name:      "RndCnstScrmblKey0",
      desc:      "Compile-time scrambling key",
      type:      "otp_ctrl_top_specific_pkg::key_t"
      randcount: "128",
      randtype:  "extdata",
    }
    { name:      "RndCnstScrmblKey1",
      desc:      "Compile-time scrambling key",
      type:      "otp_ctrl_top_specific_pkg::key_t"
      randcount: "128",
      randtype:  "extdata",
    }
    { name:      "RndCnstScrmblKey2",
      desc:      "Compile-time scrambling key",
      type:      "otp_ctrl_top_specific_pkg::key_t"
      randcount: "128",
      randtype:  "extdata",
    }
    { name:      "RndCnstScrmblKey3",
      desc:      "Compile-time scrambling key",
      type:      "otp_ctrl_top_specific_pkg::key_t"
      randcount: "128",
      randtype:  "extdata",
    }
    { name:      "RndCnstDigestConst0",
      desc:      "Compile-time digest const",
      type:      "otp_ctrl_top_specific_pkg::digest_const_t"
      randcount: "128",
      randtype:  "extdata",
    }
    { name:      "RndCnstDigestConst1",
      desc:      "Compile-time digest const",
      type:      "otp_ctrl_top_specific_pkg::digest_const_t"
      randcount: "128",
      randtype:  "extdata",
    }
    { name:      "RndCnstDigestConst2",
      desc:      "Compile-time digest const",
      type:      "otp_ctrl_top_specific_pkg::digest_const_t"
      randcount: "128",
      randtype:  "extdata",
    }
    { name:      "RndCnstDigestConst3",
      desc:      "Compile-time digest const",
      type:      "otp_ctrl_top_specific_pkg::digest_const_t"
      randcount: "128",
      randtype:  "extdata",
    }
    { name:      "RndCnstDigestIV0",
      desc:      "Compile-time digest initial vector",
      type:      "otp_ctrl_top_specific_pkg::digest_iv_t"
      randcount: "64",
      randtype:  "extdata",
    }
    { name:      "RndCnstDigestIV1",
      desc:      "Compile-time digest initial vector",
      type:      "otp_ctrl_top_specific_pkg::digest_iv_t"
      randcount: "64",
      randtype:  "extdata",
    }
    { name:      "RndCnstDigestIV2",
      desc:      "Compile-time digest initial vector",
      type:      "otp_ctrl_top_specific_pkg::digest_iv_t"
      randcount: "64",
      randtype:  "extdata",
    }
    { name:      "RndCnstDigestIV3",
      desc:      "Compile-time digest initial vector",
      type:      "otp_ctrl_top_specific_pkg::digest_iv_t"
      randcount: "64",
      randtype:  "extdata",
    }

    { name:      "RndCnstPartInvDefault",
      desc:      "OTP invalid partition default for buffered partitions",
      type:      "logic [17919:0]"
      randcount: "17920",
      randtype:  "extdata",
    }
    // Normal parameters
    { name: "NumSramKeyReqSlots",
      desc: "Number of key slots",
      type: "int",
      default: "5",
      local: "true"
    },
    // Macro parameters
    {
      name: "OtpDepth",
      desc: "Number of native words.",
      default: "1120",
      local: "true"
    },
    {
      name: "OtpWidth",
      desc: "Number of bytes in native words.",
      default: "2",
      local: "true"
    },
    {
      name: "OtpSizeWidth",
      desc: "Number of bits to represent the native words per transaction.",
      default: "2",
      local: "true"
    },
    { name: "OtpByteAddrWidth",
      desc: "Width of the OTP byte address.",
      type: "int",
      default: "12",
      local: "true"
    },
    { name: "NumErrorEntries",
      desc: "Number of error register entries.",
      type: "int",
      default: "14", // partitions + DAI/LCI
      local: "true"
    },
    { name: "NumDaiWords",
      desc: "Number of 32bit words in the DAI.",
      type: "int",
      default: "2",
      local: "true"
    },
    { name: "NumDigestWords",
      desc: "Size of the digest fields in 32bit words.",
      type: "int",
      default: "2",
      local: "true"
    },
    { name: "NumSwCfgWindowWords",
      desc: "Size of the TL-UL window in 32bit words. Note that the effective partition size is smaller than that.",
      type: "int",
      default: "1024",
      local: "true"
    }

    // Memory map Info
    { name: "NumPart",
      desc: "Number of partitions",
      type: "int",
      default: "12",
      local: "true"
    },
    { name: "NumPartUnbuf",
      desc: "Number of unbuffered partitions",
      type: "int",
      default: "5",
      local: "true"
    },
    { name: "NumPartBuf",
      desc: "Number of buffered partitions (including 1 lifecycle partition)",
      type: "int",
      default: "7",
      local: "true"
    },
    { name: "VendorTestOffset",
      desc: "Offset of the VENDOR_TEST partition",
      type: "int",
      default: "0",
      local: "true"
    },
    { name: "VendorTestSize",
      desc: "Size of the VENDOR_TEST partition",
      type: "int",
      default: "64",
      local: "true"
    },
    { name: "ScratchOffset",
      desc: "Offset of SCRATCH",
      type: "int",
      default: "0",
      local: "true"
    },
    { name: "ScratchSize",
      desc: "Size of SCRATCH",
      type: "int",
      default: "56",
      local: "true"
    },
    { name: "VendorTestDigestOffset",
      desc: "Offset of VENDOR_TEST_DIGEST",
      type: "int",
      default: "56",
      local: "true"
    },
    { name: "VendorTestDigestSize",
      desc: "Size of VENDOR_TEST_DIGEST",
      type: "int",
      default: "8",
      local: "true"
    },
    { name: "CreatorSwCfgOffset",
      desc: "Offset of the CREATOR_SW_CFG partition",
      type: "int",
      default: "64",
      local: "true"
    },
    { name: "CreatorSwCfgSize",
      desc: "Size of the CREATOR_SW_CFG partition",
      type: "int",
      default: "400",
      local: "true"
    },
    { name: "CreatorSwCfgAstCfgOffset",
      desc: "Offset of CREATOR_SW_CFG_AST_CFG",
      type: "int",
      default: "64",
      local: "true"
    },
    { name: "CreatorSwCfgAstCfgSize",
      desc: "Size of CREATOR_SW_CFG_AST_CFG",
      type: "int",
      default: "216",
      local: "true"
    },
    { name: "CreatorSwCfgAstInitEnOffset",
      desc: "Offset of CREATOR_SW_CFG_AST_INIT_EN",
      type: "int",
      default: "280",
      local: "true"
    },
    { name: "CreatorSwCfgAstInitEnSize",
      desc: "Size of CREATOR_SW_CFG_AST_INIT_EN",
      type: "int",
      default: "4",
      local: "true"
    },
    { name: "CreatorSwCfgRomExtSkuOffset",
      desc: "Offset of CREATOR_SW_CFG_ROM_EXT_SKU",
      type: "int",
      default: "284",
      local: "true"
    },
    { name: "CreatorSwCfgRomExtSkuSize",
      desc: "Size of CREATOR_SW_CFG_ROM_EXT_SKU",
      type: "int",
      default: "4",
      local: "true"
    },
    { name: "CreatorSwCfgSigverifySpxEnOffset",
      desc: "Offset of CREATOR_SW_CFG_SIGVERIFY_SPX_EN",
      type: "int",
      default: "288",
      local: "true"
    },
    { name: "CreatorSwCfgSigverifySpxEnSize",
      desc: "Size of CREATOR_SW_CFG_SIGVERIFY_SPX_EN",
      type: "int",
      default: "4",
      local: "true"
    },
    { name: "CreatorSwCfgNvmDataDefaultCfgOffset",
      desc: "Offset of CREATOR_SW_CFG_NVM_DATA_DEFAULT_CFG",
      type: "int",
      default: "292",
      local: "true"
    },
    { name: "CreatorSwCfgNvmDataDefaultCfgSize",
      desc: "Size of CREATOR_SW_CFG_NVM_DATA_DEFAULT_CFG",
      type: "int",
      default: "4",
      local: "true"
    },
    { name: "CreatorSwCfgNvmInfoBootDataCfgOffset",
      desc: "Offset of CREATOR_SW_CFG_NVM_INFO_BOOT_DATA_CFG",
      type: "int",
      default: "296",
      local: "true"
    },
    { name: "CreatorSwCfgNvmInfoBootDataCfgSize",
      desc: "Size of CREATOR_SW_CFG_NVM_INFO_BOOT_DATA_CFG",
      type: "int",
      default: "4",
      local: "true"
    },
    { name: "CreatorSwCfgNvmHwInfoCfgOverrideOffset",
      desc: "Offset of CREATOR_SW_CFG_NVM_HW_INFO_CFG_OVERRIDE",
      type: "int",
      default: "300",
      local: "true"
    },
    { name: "CreatorSwCfgNvmHwInfoCfgOverrideSize",
      desc: "Size of CREATOR_SW_CFG_NVM_HW_INFO_CFG_OVERRIDE",
      type: "int",
      default: "4",
      local: "true"
    },
    { name: "CreatorSwCfgRngEnOffset",
      desc: "Offset of CREATOR_SW_CFG_RNG_EN",
      type: "int",
      default: "304",
      local: "true"
    },
    { name: "CreatorSwCfgRngEnSize",
      desc: "Size of CREATOR_SW_CFG_RNG_EN",
      type: "int",
      default: "4",
      local: "true"
    },
    { name: "CreatorSwCfgJitterEnOffset",
      desc: "Offset of CREATOR_SW_CFG_JITTER_EN",
      type: "int",
      default: "308",
      local: "true"
    },
    { name: "CreatorSwCfgJitterEnSize",
      desc: "Size of CREATOR_SW_CFG_JITTER_EN",
      type: "int",
      default: "4",
      local: "true"
    },
    { name: "CreatorSwCfgRetRamResetMaskOffset",
      desc: "Offset of CREATOR_SW_CFG_RET_RAM_RESET_MASK",
      type: "int",
      default: "312",
      local: "true"
    },
    { name: "CreatorSwCfgRetRamResetMaskSize",
      desc: "Size of CREATOR_SW_CFG_RET_RAM_RESET_MASK",
      type: "int",
      default: "4",
      local: "true"
    },
    { name: "CreatorSwCfgManufStateOffset",
      desc: "Offset of CREATOR_SW_CFG_MANUF_STATE",
      type: "int",
      default: "316",
      local: "true"
    },
    { name: "CreatorSwCfgManufStateSize",
      desc: "Size of CREATOR_SW_CFG_MANUF_STATE",
      type: "int",
      default: "4",
      local: "true"
    },
    { name: "CreatorSwCfgRomExecEnOffset",
      desc: "Offset of CREATOR_SW_CFG_ROM_EXEC_EN",
      type: "int",
      default: "320",
      local: "true"
    },
    { name: "CreatorSwCfgRomExecEnSize",
      desc: "Size of CREATOR_SW_CFG_ROM_EXEC_EN",
      type: "int",
      default: "4",
      local: "true"
    },
    { name: "CreatorSwCfgCpuctrlOffset",
      desc: "Offset of CREATOR_SW_CFG_CPUCTRL",
      type: "int",
      default: "324",
      local: "true"
    },
    { name: "CreatorSwCfgCpuctrlSize",
      desc: "Size of CREATOR_SW_CFG_CPUCTRL",
      type: "int",
      default: "4",
      local: "true"
    },
    { name: "CreatorSwCfgMinSecVerRomExtOffset",
      desc: "Offset of CREATOR_SW_CFG_MIN_SEC_VER_ROM_EXT",
      type: "int",
      default: "328",
      local: "true"
    },
    { name: "CreatorSwCfgMinSecVerRomExtSize",
      desc: "Size of CREATOR_SW_CFG_MIN_SEC_VER_ROM_EXT",
      type: "int",
      default: "4",
      local: "true"
    },
    { name: "CreatorSwCfgMinSecVerBl0Offset",
      desc: "Offset of CREATOR_SW_CFG_MIN_SEC_VER_BL0",
      type: "int",
      default: "332",
      local: "true"
    },
    { name: "CreatorSwCfgMinSecVerBl0Size",
      desc: "Size of CREATOR_SW_CFG_MIN_SEC_VER_BL0",
      type: "int",
      default: "4",
      local: "true"
    },
    { name: "CreatorSwCfgDefaultBootDataInProdEnOffset",
      desc: "Offset of CREATOR_SW_CFG_DEFAULT_BOOT_DATA_IN_PROD_EN",
      type: "int",
      default: "336",
      local: "true"
    },
    { name: "CreatorSwCfgDefaultBootDataInProdEnSize",
      desc: "Size of CREATOR_SW_CFG_DEFAULT_BOOT_DATA_IN_PROD_EN",
      type: "int",
      default: "4",
      local: "true"
    },
    { name: "CreatorSwCfgRmaSpinEnOffset",
      desc: "Offset of CREATOR_SW_CFG_RMA_SPIN_EN",
      type: "int",
      default: "340",
      local: "true"
    },
    { name: "CreatorSwCfgRmaSpinEnSize",
      desc: "Size of CREATOR_SW_CFG_RMA_SPIN_EN",
      type: "int",
      default: "4",
      local: "true"
    },
    { name: "CreatorSwCfgRmaSpinCyclesOffset",
      desc: "Offset of CREATOR_SW_CFG_RMA_SPIN_CYCLES",
      type: "int",
      default: "344",
      local: "true"
    },
    { name: "CreatorSwCfgRmaSpinCyclesSize",
      desc: "Size of CREATOR_SW_CFG_RMA_SPIN_CYCLES",
      type: "int",
      default: "4",
      local: "true"
    },
    { name: "CreatorSwCfgRngRepcntThresholdsOffset",
      desc: "Offset of CREATOR_SW_CFG_RNG_REPCNT_THRESHOLDS",
      type: "int",
      default: "348",
      local: "true"
    },
    { name: "CreatorSwCfgRngRepcntThresholdsSize",
      desc: "Size of CREATOR_SW_CFG_RNG_REPCNT_THRESHOLDS",
      type: "int",
      default: "4",
      local: "true"
    },
    { name: "CreatorSwCfgRngRepcntsThresholdsOffset",
      desc: "Offset of CREATOR_SW_CFG_RNG_REPCNTS_THRESHOLDS",
      type: "int",
      default: "352",
      local: "true"
    },
    { name: "CreatorSwCfgRngRepcntsThresholdsSize",
      desc: "Size of CREATOR_SW_CFG_RNG_REPCNTS_THRESHOLDS",
      type: "int",
      default: "4",
      local: "true"
    },
    { name: "CreatorSwCfgRngAdaptpHiThresholdsOffset",
      desc: "Offset of CREATOR_SW_CFG_RNG_ADAPTP_HI_THRESHOLDS",
      type: "int",
      default: "356",
      local: "true"
    },
    { name: "CreatorSwCfgRngAdaptpHiThresholdsSize",
      desc: "Size of CREATOR_SW_CFG_RNG_ADAPTP_HI_THRESHOLDS",
      type: "int",
      default: "4",
      local: "true"
    },
    { name: "CreatorSwCfgRngAdaptpLoThresholdsOffset",
      desc: "Offset of CREATOR_SW_CFG_RNG_ADAPTP_LO_THRESHOLDS",
      type: "int",
      default: "360",
      local: "true"
    },
    { name: "CreatorSwCfgRngAdaptpLoThresholdsSize",
      desc: "Size of CREATOR_SW_CFG_RNG_ADAPTP_LO_THRESHOLDS",
      type: "int",
      default: "4",
      local: "true"
    },
    { name: "CreatorSwCfgRngAdaptpsThresholdsOffset",
      desc: "Offset of CREATOR_SW_CFG_RNG_ADAPTPS_THRESHOLDS",
      type: "int",
      default: "364",
      local: "true"
    },
    { name: "CreatorSwCfgRngAdaptpsThresholdsSize",
      desc: "Size of CREATOR_SW_CFG_RNG_ADAPTPS_THRESHOLDS",
      type: "int",
      default: "4",
      local: "true"
    },
    { name: "CreatorSwCfgRngBucketThresholdsOffset",
      desc: "Offset of CREATOR_SW_CFG_RNG_BUCKET_THRESHOLDS",
      type: "int",
      default: "368",
      local: "true"
    },
    { name: "CreatorSwCfgRngBucketThresholdsSize",
      desc: "Size of CREATOR_SW_CFG_RNG_BUCKET_THRESHOLDS",
      type: "int",
      default: "4",
      local: "true"
    },
    { name: "CreatorSwCfgRngMarkovHiThresholdsOffset",
      desc: "Offset of CREATOR_SW_CFG_RNG_MARKOV_HI_THRESHOLDS",
      type: "int",
      default: "372",
      local: "true"
    },
    { name: "CreatorSwCfgRngMarkovHiThresholdsSize",
      desc: "Size of CREATOR_SW_CFG_RNG_MARKOV_HI_THRESHOLDS",
      type: "int",
      default: "4",
      local: "true"
    },
    { name: "CreatorSwCfgRngMarkovLoThresholdsOffset",
      desc: "Offset of CREATOR_SW_CFG_RNG_MARKOV_LO_THRESHOLDS",
      type: "int",
      default: "376",
      local: "true"
    },
    { name: "CreatorSwCfgRngMarkovLoThresholdsSize",
      desc: "Size of CREATOR_SW_CFG_RNG_MARKOV_LO_THRESHOLDS",
      type: "int",
      default: "4",
      local: "true"
    },
    { name: "CreatorSwCfgRngExthtHiThresholdsOffset",
      desc: "Offset of CREATOR_SW_CFG_RNG_EXTHT_HI_THRESHOLDS",
      type: "int",
      default: "380",
      local: "true"
    },
    { name: "CreatorSwCfgRngExthtHiThresholdsSize",
      desc: "Size of CREATOR_SW_CFG_RNG_EXTHT_HI_THRESHOLDS",
      type: "int",
      default: "4",
      local: "true"
    },
    { name: "CreatorSwCfgRngExthtLoThresholdsOffset",
      desc: "Offset of CREATOR_SW_CFG_RNG_EXTHT_LO_THRESHOLDS",
      type: "int",
      default: "384",
      local: "true"
    },
    { name: "CreatorSwCfgRngExthtLoThresholdsSize",
      desc: "Size of CREATOR_SW_CFG_RNG_EXTHT_LO_THRESHOLDS",
      type: "int",
      default: "4",
      local: "true"
    },
    { name: "CreatorSwCfgRngBootAlertThresholdOffset",
      desc: "Offset of CREATOR_SW_CFG_RNG_BOOT_ALERT_THRESHOLD",
      type: "int",
      default: "388",
      local: "true"
    },
    { name: "CreatorSwCfgRngBootAlertThresholdSize",
      desc: "Size of CREATOR_SW_CFG_RNG_BOOT_ALERT_THRESHOLD",
      type: "int",
      default: "4",
      local: "true"
    },
    { name: "CreatorSwCfgRngFipsAlertThresholdOffset",
      desc: "Offset of CREATOR_SW_CFG_RNG_FIPS_ALERT_THRESHOLD",
      type: "int",
      default: "392",
      local: "true"
    },
    { name: "CreatorSwCfgRngFipsAlertThresholdSize",
      desc: "Size of CREATOR_SW_CFG_RNG_FIPS_ALERT_THRESHOLD",
      type: "int",
      default: "4",
      local: "true"
    },
    { name: "CreatorSwCfgRngBootConfigDigestOffset",
      desc: "Offset of CREATOR_SW_CFG_RNG_BOOT_CONFIG_DIGEST",
      type: "int",
      default: "396",
      local: "true"
    },
    { name: "CreatorSwCfgRngBootConfigDigestSize",
      desc: "Size of CREATOR_SW_CFG_RNG_BOOT_CONFIG_DIGEST",
      type: "int",
      default: "4",
      local: "true"
    },
    { name: "CreatorSwCfgRngFipsConfigDigestOffset",
      desc: "Offset of CREATOR_SW_CFG_RNG_FIPS_CONFIG_DIGEST",
      type: "int",
      default: "400",
      local: "true"
    },
    { name: "CreatorSwCfgRngFipsConfigDigestSize",
      desc: "Size of CREATOR_SW_CFG_RNG_FIPS_CONFIG_DIGEST",
      type: "int",
      default: "4",
      local: "true"
    },
    { name: "CreatorSwCfgSramKeyRenewAndInitEnOffset",
      desc: "Offset of CREATOR_SW_CFG_SRAM_KEY_RENEW_AND_INIT_EN",
      type: "int",
      default: "404",
      local: "true"
    },
    { name: "CreatorSwCfgSramKeyRenewAndInitEnSize",
      desc: "Size of CREATOR_SW_CFG_SRAM_KEY_RENEW_AND_INIT_EN",
      type: "int",
      default: "4",
      local: "true"
    },
    { name: "CreatorSwCfgImmutableRomExtEnOffset",
      desc: "Offset of CREATOR_SW_CFG_IMMUTABLE_ROM_EXT_EN",
      type: "int",
      default: "408",
      local: "true"
    },
    { name: "CreatorSwCfgImmutableRomExtEnSize",
      desc: "Size of CREATOR_SW_CFG_IMMUTABLE_ROM_EXT_EN",
      type: "int",
      default: "4",
      local: "true"
    },
    { name: "CreatorSwCfgImmutableRomExtStartOffsetOffset",
      desc: "Offset of CREATOR_SW_CFG_IMMUTABLE_ROM_EXT_START_OFFSET",
      type: "int",
      default: "412",
      local: "true"
    },
    { name: "CreatorSwCfgImmutableRomExtStartOffsetSize",
      desc: "Size of CREATOR_SW_CFG_IMMUTABLE_ROM_EXT_START_OFFSET",
      type: "int",
      default: "4",
      local: "true"
    },
    { name: "CreatorSwCfgImmutableRomExtLengthOffset",
      desc: "Offset of CREATOR_SW_CFG_IMMUTABLE_ROM_EXT_LENGTH",
      type: "int",
      default: "416",
      local: "true"
    },
    { name: "CreatorSwCfgImmutableRomExtLengthSize",
      desc: "Size of CREATOR_SW_CFG_IMMUTABLE_ROM_EXT_LENGTH",
      type: "int",
      default: "4",
      local: "true"
    },
    { name: "CreatorSwCfgImmutableRomExtSha256HashOffset",
      desc: "Offset of CREATOR_SW_CFG_IMMUTABLE_ROM_EXT_SHA256_HASH",
      type: "int",
      default: "420",
      local: "true"
    },
    { name: "CreatorSwCfgImmutableRomExtSha256HashSize",
      desc: "Size of CREATOR_SW_CFG_IMMUTABLE_ROM_EXT_SHA256_HASH",
      type: "int",
      default: "32",
      local: "true"
    },
    { name: "CreatorSwCfgDigestOffset",
      desc: "Offset of CREATOR_SW_CFG_DIGEST",
      type: "int",
      default: "456",
      local: "true"
    },
    { name: "CreatorSwCfgDigestSize",
      desc: "Size of CREATOR_SW_CFG_DIGEST",
      type: "int",
      default: "8",
      local: "true"
    },
    { name: "OwnerSwCfgOffset",
      desc: "Offset of the OWNER_SW_CFG partition",
      type: "int",
      default: "464",
      local: "true"
    },
    { name: "OwnerSwCfgSize",
      desc: "Size of the OWNER_SW_CFG partition",
      type: "int",
      default: "672",
      local: "true"
    },
    { name: "OwnerSwCfgRomErrorReportingOffset",
      desc: "Offset of OWNER_SW_CFG_ROM_ERROR_REPORTING",
      type: "int",
      default: "464",
      local: "true"
    },
    { name: "OwnerSwCfgRomErrorReportingSize",
      desc: "Size of OWNER_SW_CFG_ROM_ERROR_REPORTING",
      type: "int",
      default: "4",
      local: "true"
    },
    { name: "OwnerSwCfgRomBootstrapDisOffset",
      desc: "Offset of OWNER_SW_CFG_ROM_BOOTSTRAP_DIS",
      type: "int",
      default: "468",
      local: "true"
    },
    { name: "OwnerSwCfgRomBootstrapDisSize",
      desc: "Size of OWNER_SW_CFG_ROM_BOOTSTRAP_DIS",
      type: "int",
      default: "4",
      local: "true"
    },
    { name: "OwnerSwCfgRomAlertClassEnOffset",
      desc: "Offset of OWNER_SW_CFG_ROM_ALERT_CLASS_EN",
      type: "int",
      default: "472",
      local: "true"
    },
    { name: "OwnerSwCfgRomAlertClassEnSize",
      desc: "Size of OWNER_SW_CFG_ROM_ALERT_CLASS_EN",
      type: "int",
      default: "4",
      local: "true"
    },
    { name: "OwnerSwCfgRomAlertEscalationOffset",
      desc: "Offset of OWNER_SW_CFG_ROM_ALERT_ESCALATION",
      type: "int",
      default: "476",
      local: "true"
    },
    { name: "OwnerSwCfgRomAlertEscalationSize",
      desc: "Size of OWNER_SW_CFG_ROM_ALERT_ESCALATION",
      type: "int",
      default: "4",
      local: "true"
    },
    { name: "OwnerSwCfgRomAlertClassificationOffset",
      desc: "Offset of OWNER_SW_CFG_ROM_ALERT_CLASSIFICATION",
      type: "int",
      default: "480",
      local: "true"
    },
    { name: "OwnerSwCfgRomAlertClassificationSize",
      desc: "Size of OWNER_SW_CFG_ROM_ALERT_CLASSIFICATION",
      type: "int",
      default: "320",
      local: "true"
    },
    { name: "OwnerSwCfgRomLocalAlertClassificationOffset",
      desc: "Offset of OWNER_SW_CFG_ROM_LOCAL_ALERT_CLASSIFICATION",
      type: "int",
      default: "800",
      local: "true"
    },
    { name: "OwnerSwCfgRomLocalAlertClassificationSize",
      desc: "Size of OWNER_SW_CFG_ROM_LOCAL_ALERT_CLASSIFICATION",
      type: "int",
      default: "64",
      local: "true"
    },
    { name: "OwnerSwCfgRomAlertAccumThreshOffset",
      desc: "Offset of OWNER_SW_CFG_ROM_ALERT_ACCUM_THRESH",
      type: "int",
      default: "864",
      local: "true"
    },
    { name: "OwnerSwCfgRomAlertAccumThreshSize",
      desc: "Size of OWNER_SW_CFG_ROM_ALERT_ACCUM_THRESH",
      type: "int",
      default: "16",
      local: "true"
    },
    { name: "OwnerSwCfgRomAlertTimeoutCyclesOffset",
      desc: "Offset of OWNER_SW_CFG_ROM_ALERT_TIMEOUT_CYCLES",
      type: "int",
      default: "880",
      local: "true"
    },
    { name: "OwnerSwCfgRomAlertTimeoutCyclesSize",
      desc: "Size of OWNER_SW_CFG_ROM_ALERT_TIMEOUT_CYCLES",
      type: "int",
      default: "16",
      local: "true"
    },
    { name: "OwnerSwCfgRomAlertPhaseCyclesOffset",
      desc: "Offset of OWNER_SW_CFG_ROM_ALERT_PHASE_CYCLES",
      type: "int",
      default: "896",
      local: "true"
    },
    { name: "OwnerSwCfgRomAlertPhaseCyclesSize",
      desc: "Size of OWNER_SW_CFG_ROM_ALERT_PHASE_CYCLES",
      type: "int",
      default: "64",
      local: "true"
    },
    { name: "OwnerSwCfgRomAlertDigestProdOffset",
      desc: "Offset of OWNER_SW_CFG_ROM_ALERT_DIGEST_PROD",
      type: "int",
      default: "960",
      local: "true"
    },
    { name: "OwnerSwCfgRomAlertDigestProdSize",
      desc: "Size of OWNER_SW_CFG_ROM_ALERT_DIGEST_PROD",
      type: "int",
      default: "4",
      local: "true"
    },
    { name: "OwnerSwCfgRomAlertDigestProdEndOffset",
      desc: "Offset of OWNER_SW_CFG_ROM_ALERT_DIGEST_PROD_END",
      type: "int",
      default: "964",
      local: "true"
    },
    { name: "OwnerSwCfgRomAlertDigestProdEndSize",
      desc: "Size of OWNER_SW_CFG_ROM_ALERT_DIGEST_PROD_END",
      type: "int",
      default: "4",
      local: "true"
    },
    { name: "OwnerSwCfgRomAlertDigestDevOffset",
      desc: "Offset of OWNER_SW_CFG_ROM_ALERT_DIGEST_DEV",
      type: "int",
      default: "968",
      local: "true"
    },
    { name: "OwnerSwCfgRomAlertDigestDevSize",
      desc: "Size of OWNER_SW_CFG_ROM_ALERT_DIGEST_DEV",
      type: "int",
      default: "4",
      local: "true"
    },
    { name: "OwnerSwCfgRomAlertDigestRmaOffset",
      desc: "Offset of OWNER_SW_CFG_ROM_ALERT_DIGEST_RMA",
      type: "int",
      default: "972",
      local: "true"
    },
    { name: "OwnerSwCfgRomAlertDigestRmaSize",
      desc: "Size of OWNER_SW_CFG_ROM_ALERT_DIGEST_RMA",
      type: "int",
      default: "4",
      local: "true"
    },
    { name: "OwnerSwCfgRomWatchdogBiteThresholdCyclesOffset",
      desc: "Offset of OWNER_SW_CFG_ROM_WATCHDOG_BITE_THRESHOLD_CYCLES",
      type: "int",
      default: "976",
      local: "true"
    },
    { name: "OwnerSwCfgRomWatchdogBiteThresholdCyclesSize",
      desc: "Size of OWNER_SW_CFG_ROM_WATCHDOG_BITE_THRESHOLD_CYCLES",
      type: "int",
      default: "4",
      local: "true"
    },
    { name: "OwnerSwCfgRomKeymgrOtpMeasEnOffset",
      desc: "Offset of OWNER_SW_CFG_ROM_KEYMGR_OTP_MEAS_EN",
      type: "int",
      default: "980",
      local: "true"
    },
    { name: "OwnerSwCfgRomKeymgrOtpMeasEnSize",
      desc: "Size of OWNER_SW_CFG_ROM_KEYMGR_OTP_MEAS_EN",
      type: "int",
      default: "4",
      local: "true"
    },
    { name: "OwnerSwCfgRomKeymgrDisableOffset",
      desc: "Offset of OWNER_SW_CFG_ROM_KEYMGR_DISABLE",
      type: "int",
      default: "984",
      local: "true"
    },
    { name: "OwnerSwCfgRomKeymgrDisableSize",
      desc: "Size of OWNER_SW_CFG_ROM_KEYMGR_DISABLE",
      type: "int",
      default: "4",
      local: "true"
    },
    { name: "OwnerSwCfgRomKeymgrKdfEngineSelectionOffset",
      desc: "Offset of OWNER_SW_CFG_ROM_KEYMGR_KDF_ENGINE_SELECTION",
      type: "int",
      default: "988",
      local: "true"
    },
    { name: "OwnerSwCfgRomKeymgrKdfEngineSelectionSize",
      desc: "Size of OWNER_SW_CFG_ROM_KEYMGR_KDF_ENGINE_SELECTION",
      type: "int",
      default: "4",
      local: "true"
    },
    { name: "OwnerSwCfgRomKeymgrKdfEngineSelectionRegwenOffset",
      desc: "Offset of OWNER_SW_CFG_ROM_KEYMGR_KDF_ENGINE_SELECTION_REGWEN",
      type: "int",
      default: "992",
      local: "true"
    },
    { name: "OwnerSwCfgRomKeymgrKdfEngineSelectionRegwenSize",
      desc: "Size of OWNER_SW_CFG_ROM_KEYMGR_KDF_ENGINE_SELECTION_REGWEN",
      type: "int",
      default: "4",
      local: "true"
    },
    { name: "OwnerSwCfgRomKeymgrLockCreatorRootKeyOffset",
      desc: "Offset of OWNER_SW_CFG_ROM_KEYMGR_LOCK_CREATOR_ROOT_KEY",
      type: "int",
      default: "996",
      local: "true"
    },
    { name: "OwnerSwCfgRomKeymgrLockCreatorRootKeySize",
      desc: "Size of OWNER_SW_CFG_ROM_KEYMGR_LOCK_CREATOR_ROOT_KEY",
      type: "int",
      default: "4",
      local: "true"
    },
    { name: "OwnerSwCfgManufStateOffset",
      desc: "Offset of OWNER_SW_CFG_MANUF_STATE",
      type: "int",
      default: "1000",
      local: "true"
    },
    { name: "OwnerSwCfgManufStateSize",
      desc: "Size of OWNER_SW_CFG_MANUF_STATE",
      type: "int",
      default: "4",
      local: "true"
    },
    { name: "OwnerSwCfgRomRstmgrInfoEnOffset",
      desc: "Offset of OWNER_SW_CFG_ROM_RSTMGR_INFO_EN",
      type: "int",
      default: "1004",
      local: "true"
    },
    { name: "OwnerSwCfgRomRstmgrInfoEnSize",
      desc: "Size of OWNER_SW_CFG_ROM_RSTMGR_INFO_EN",
      type: "int",
      default: "4",
      local: "true"
    },
    { name: "OwnerSwCfgRomExtBootstrapEnOffset",
      desc: "Offset of OWNER_SW_CFG_ROM_EXT_BOOTSTRAP_EN",
      type: "int",
      default: "1008",
      local: "true"
    },
    { name: "OwnerSwCfgRomExtBootstrapEnSize",
      desc: "Size of OWNER_SW_CFG_ROM_EXT_BOOTSTRAP_EN",
      type: "int",
      default: "4",
      local: "true"
    },
    { name: "OwnerSwCfgRomSensorCtrlAlertCfgOffset",
      desc: "Offset of OWNER_SW_CFG_ROM_SENSOR_CTRL_ALERT_CFG",
      type: "int",
      default: "1012",
      local: "true"
    },
    { name: "OwnerSwCfgRomSensorCtrlAlertCfgSize",
      desc: "Size of OWNER_SW_CFG_ROM_SENSOR_CTRL_ALERT_CFG",
      type: "int",
      default: "12",
      local: "true"
    },
    { name: "OwnerSwCfgRomSramReadbackEnOffset",
      desc: "Offset of OWNER_SW_CFG_ROM_SRAM_READBACK_EN",
      type: "int",
      default: "1024",
      local: "true"
    },
    { name: "OwnerSwCfgRomSramReadbackEnSize",
      desc: "Size of OWNER_SW_CFG_ROM_SRAM_READBACK_EN",
      type: "int",
      default: "4",
      local: "true"
    },
    { name: "OwnerSwCfgRomPreserveResetReasonEnOffset",
      desc: "Offset of OWNER_SW_CFG_ROM_PRESERVE_RESET_REASON_EN",
      type: "int",
      default: "1028",
      local: "true"
    },
    { name: "OwnerSwCfgRomPreserveResetReasonEnSize",
      desc: "Size of OWNER_SW_CFG_ROM_PRESERVE_RESET_REASON_EN",
      type: "int",
      default: "4",
      local: "true"
    },
    { name: "OwnerSwCfgRomResetReasonCheckValueOffset",
      desc: "Offset of OWNER_SW_CFG_ROM_RESET_REASON_CHECK_VALUE",
      type: "int",
      default: "1032",
      local: "true"
    },
    { name: "OwnerSwCfgRomResetReasonCheckValueSize",
      desc: "Size of OWNER_SW_CFG_ROM_RESET_REASON_CHECK_VALUE",
      type: "int",
      default: "4",
      local: "true"
    },
    { name: "OwnerSwCfgRomBannerEnOffset",
      desc: "Offset of OWNER_SW_CFG_ROM_BANNER_EN",
      type: "int",
      default: "1036",
      local: "true"
    },
    { name: "OwnerSwCfgRomBannerEnSize",
      desc: "Size of OWNER_SW_CFG_ROM_BANNER_EN",
      type: "int",
      default: "4",
      local: "true"
    },
    { name: "OwnerSwCfgRomNvmEccExcHandlerEnOffset",
      desc: "Offset of OWNER_SW_CFG_ROM_NVM_ECC_EXC_HANDLER_EN",
      type: "int",
      default: "1040",
      local: "true"
    },
    { name: "OwnerSwCfgRomNvmEccExcHandlerEnSize",
      desc: "Size of OWNER_SW_CFG_ROM_NVM_ECC_EXC_HANDLER_EN",
      type: "int",
      default: "4",
      local: "true"
    },
    { name: "OwnerSwCfgReservedOffset",
      desc: "Offset of OWNER_SW_CFG_RESERVED",
      type: "int",
      default: "1044",
      local: "true"
    },
    { name: "OwnerSwCfgReservedSize",
      desc: "Size of OWNER_SW_CFG_RESERVED",
      type: "int",
      default: "80",
      local: "true"
    },
    { name: "OwnerSwCfgDigestOffset",
      desc: "Offset of OWNER_SW_CFG_DIGEST",
      type: "int",
      default: "1128",
      local: "true"
    },
    { name: "OwnerSwCfgDigestSize",
      desc: "Size of OWNER_SW_CFG_DIGEST",
      type: "int",
      default: "8",
      local: "true"
    },
    { name: "RotCreatorAuthCodesignOffset",
      desc: "Offset of the ROT_CREATOR_AUTH_CODESIGN partition",
      type: "int",
      default: "1136",
      local: "true"
    },
    { name: "RotCreatorAuthCodesignSize",
      desc: "Size of the ROT_CREATOR_AUTH_CODESIGN partition",
      type: "int",
      default: "472",
      local: "true"
    },
    { name: "RotCreatorAuthCodesignEcdsaKeyType0Offset",
      desc: "Offset of ROT_CREATOR_AUTH_CODESIGN_ECDSA_KEY_TYPE0",
      type: "int",
      default: "1136",
      local: "true"
    },
    { name: "RotCreatorAuthCodesignEcdsaKeyType0Size",
      desc: "Size of ROT_CREATOR_AUTH_CODESIGN_ECDSA_KEY_TYPE0",
      type: "int",
      default: "4",
      local: "true"
    },
    { name: "RotCreatorAuthCodesignEcdsaKey0Offset",
      desc: "Offset of ROT_CREATOR_AUTH_CODESIGN_ECDSA_KEY0",
      type: "int",
      default: "1140",
      local: "true"
    },
    { name: "RotCreatorAuthCodesignEcdsaKey0Size",
      desc: "Size of ROT_CREATOR_AUTH_CODESIGN_ECDSA_KEY0",
      type: "int",
      default: "64",
      local: "true"
    },
    { name: "RotCreatorAuthCodesignEcdsaKeyType1Offset",
      desc: "Offset of ROT_CREATOR_AUTH_CODESIGN_ECDSA_KEY_TYPE1",
      type: "int",
      default: "1204",
      local: "true"
    },
    { name: "RotCreatorAuthCodesignEcdsaKeyType1Size",
      desc: "Size of ROT_CREATOR_AUTH_CODESIGN_ECDSA_KEY_TYPE1",
      type: "int",
      default: "4",
      local: "true"
    },
    { name: "RotCreatorAuthCodesignEcdsaKey1Offset",
      desc: "Offset of ROT_CREATOR_AUTH_CODESIGN_ECDSA_KEY1",
      type: "int",
      default: "1208",
      local: "true"
    },
    { name: "RotCreatorAuthCodesignEcdsaKey1Size",
      desc: "Size of ROT_CREATOR_AUTH_CODESIGN_ECDSA_KEY1",
      type: "int",
      default: "64",
      local: "true"
    },
    { name: "RotCreatorAuthCodesignEcdsaKeyType2Offset",
      desc: "Offset of ROT_CREATOR_AUTH_CODESIGN_ECDSA_KEY_TYPE2",
      type: "int",
      default: "1272",
      local: "true"
    },
    { name: "RotCreatorAuthCodesignEcdsaKeyType2Size",
      desc: "Size of ROT_CREATOR_AUTH_CODESIGN_ECDSA_KEY_TYPE2",
      type: "int",
      default: "4",
      local: "true"
    },
    { name: "RotCreatorAuthCodesignEcdsaKey2Offset",
      desc: "Offset of ROT_CREATOR_AUTH_CODESIGN_ECDSA_KEY2",
      type: "int",
      default: "1276",
      local: "true"
    },
    { name: "RotCreatorAuthCodesignEcdsaKey2Size",
      desc: "Size of ROT_CREATOR_AUTH_CODESIGN_ECDSA_KEY2",
      type: "int",
      default: "64",
      local: "true"
    },
    { name: "RotCreatorAuthCodesignEcdsaKeyType3Offset",
      desc: "Offset of ROT_CREATOR_AUTH_CODESIGN_ECDSA_KEY_TYPE3",
      type: "int",
      default: "1340",
      local: "true"
    },
    { name: "RotCreatorAuthCodesignEcdsaKeyType3Size",
      desc: "Size of ROT_CREATOR_AUTH_CODESIGN_ECDSA_KEY_TYPE3",
      type: "int",
      default: "4",
      local: "true"
    },
    { name: "RotCreatorAuthCodesignEcdsaKey3Offset",
      desc: "Offset of ROT_CREATOR_AUTH_CODESIGN_ECDSA_KEY3",
      type: "int",
      default: "1344",
      local: "true"
    },
    { name: "RotCreatorAuthCodesignEcdsaKey3Size",
      desc: "Size of ROT_CREATOR_AUTH_CODESIGN_ECDSA_KEY3",
      type: "int",
      default: "64",
      local: "true"
    },
    { name: "RotCreatorAuthCodesignSpxKeyType0Offset",
      desc: "Offset of ROT_CREATOR_AUTH_CODESIGN_SPX_KEY_TYPE0",
      type: "int",
      default: "1408",
      local: "true"
    },
    { name: "RotCreatorAuthCodesignSpxKeyType0Size",
      desc: "Size of ROT_CREATOR_AUTH_CODESIGN_SPX_KEY_TYPE0",
      type: "int",
      default: "4",
      local: "true"
    },
    { name: "RotCreatorAuthCodesignSpxKey0Offset",
      desc: "Offset of ROT_CREATOR_AUTH_CODESIGN_SPX_KEY0",
      type: "int",
      default: "1412",
      local: "true"
    },
    { name: "RotCreatorAuthCodesignSpxKey0Size",
      desc: "Size of ROT_CREATOR_AUTH_CODESIGN_SPX_KEY0",
      type: "int",
      default: "32",
      local: "true"
    },
    { name: "RotCreatorAuthCodesignSpxKeyConfig0Offset",
      desc: "Offset of ROT_CREATOR_AUTH_CODESIGN_SPX_KEY_CONFIG0",
      type: "int",
      default: "1444",
      local: "true"
    },
    { name: "RotCreatorAuthCodesignSpxKeyConfig0Size",
      desc: "Size of ROT_CREATOR_AUTH_CODESIGN_SPX_KEY_CONFIG0",
      type: "int",
      default: "4",
      local: "true"
    },
    { name: "RotCreatorAuthCodesignSpxKeyType1Offset",
      desc: "Offset of ROT_CREATOR_AUTH_CODESIGN_SPX_KEY_TYPE1",
      type: "int",
      default: "1448",
      local: "true"
    },
    { name: "RotCreatorAuthCodesignSpxKeyType1Size",
      desc: "Size of ROT_CREATOR_AUTH_CODESIGN_SPX_KEY_TYPE1",
      type: "int",
      default: "4",
      local: "true"
    },
    { name: "RotCreatorAuthCodesignSpxKey1Offset",
      desc: "Offset of ROT_CREATOR_AUTH_CODESIGN_SPX_KEY1",
      type: "int",
      default: "1452",
      local: "true"
    },
    { name: "RotCreatorAuthCodesignSpxKey1Size",
      desc: "Size of ROT_CREATOR_AUTH_CODESIGN_SPX_KEY1",
      type: "int",
      default: "32",
      local: "true"
    },
    { name: "RotCreatorAuthCodesignSpxKeyConfig1Offset",
      desc: "Offset of ROT_CREATOR_AUTH_CODESIGN_SPX_KEY_CONFIG1",
      type: "int",
      default: "1484",
      local: "true"
    },
    { name: "RotCreatorAuthCodesignSpxKeyConfig1Size",
      desc: "Size of ROT_CREATOR_AUTH_CODESIGN_SPX_KEY_CONFIG1",
      type: "int",
      default: "4",
      local: "true"
    },
    { name: "RotCreatorAuthCodesignSpxKeyType2Offset",
      desc: "Offset of ROT_CREATOR_AUTH_CODESIGN_SPX_KEY_TYPE2",
      type: "int",
      default: "1488",
      local: "true"
    },
    { name: "RotCreatorAuthCodesignSpxKeyType2Size",
      desc: "Size of ROT_CREATOR_AUTH_CODESIGN_SPX_KEY_TYPE2",
      type: "int",
      default: "4",
      local: "true"
    },
    { name: "RotCreatorAuthCodesignSpxKey2Offset",
      desc: "Offset of ROT_CREATOR_AUTH_CODESIGN_SPX_KEY2",
      type: "int",
      default: "1492",
      local: "true"
    },
    { name: "RotCreatorAuthCodesignSpxKey2Size",
      desc: "Size of ROT_CREATOR_AUTH_CODESIGN_SPX_KEY2",
      type: "int",
      default: "32",
      local: "true"
    },
    { name: "RotCreatorAuthCodesignSpxKeyConfig2Offset",
      desc: "Offset of ROT_CREATOR_AUTH_CODESIGN_SPX_KEY_CONFIG2",
      type: "int",
      default: "1524",
      local: "true"
    },
    { name: "RotCreatorAuthCodesignSpxKeyConfig2Size",
      desc: "Size of ROT_CREATOR_AUTH_CODESIGN_SPX_KEY_CONFIG2",
      type: "int",
      default: "4",
      local: "true"
    },
    { name: "RotCreatorAuthCodesignSpxKeyType3Offset",
      desc: "Offset of ROT_CREATOR_AUTH_CODESIGN_SPX_KEY_TYPE3",
      type: "int",
      default: "1528",
      local: "true"
    },
    { name: "RotCreatorAuthCodesignSpxKeyType3Size",
      desc: "Size of ROT_CREATOR_AUTH_CODESIGN_SPX_KEY_TYPE3",
      type: "int",
      default: "4",
      local: "true"
    },
    { name: "RotCreatorAuthCodesignSpxKey3Offset",
      desc: "Offset of ROT_CREATOR_AUTH_CODESIGN_SPX_KEY3",
      type: "int",
      default: "1532",
      local: "true"
    },
    { name: "RotCreatorAuthCodesignSpxKey3Size",
      desc: "Size of ROT_CREATOR_AUTH_CODESIGN_SPX_KEY3",
      type: "int",
      default: "32",
      local: "true"
    },
    { name: "RotCreatorAuthCodesignSpxKeyConfig3Offset",
      desc: "Offset of ROT_CREATOR_AUTH_CODESIGN_SPX_KEY_CONFIG3",
      type: "int",
      default: "1564",
      local: "true"
    },
    { name: "RotCreatorAuthCodesignSpxKeyConfig3Size",
      desc: "Size of ROT_CREATOR_AUTH_CODESIGN_SPX_KEY_CONFIG3",
      type: "int",
      default: "4",
      local: "true"
    },
    { name: "RotCreatorAuthCodesignBlockSha2_256HashOffset",
      desc: "Offset of ROT_CREATOR_AUTH_CODESIGN_BLOCK_SHA2_256_HASH",
      type: "int",
      default: "1568",
      local: "true"
    },
    { name: "RotCreatorAuthCodesignBlockSha2_256HashSize",
      desc: "Size of ROT_CREATOR_AUTH_CODESIGN_BLOCK_SHA2_256_HASH",
      type: "int",
      default: "32",
      local: "true"
    },
    { name: "RotCreatorAuthCodesignDigestOffset",
      desc: "Offset of ROT_CREATOR_AUTH_CODESIGN_DIGEST",
      type: "int",
      default: "1600",
      local: "true"
    },
    { name: "RotCreatorAuthCodesignDigestSize",
      desc: "Size of ROT_CREATOR_AUTH_CODESIGN_DIGEST",
      type: "int",
      default: "8",
      local: "true"
    },
    { name: "RotCreatorAuthStateOffset",
      desc: "Offset of the ROT_CREATOR_AUTH_STATE partition",
      type: "int",
      default: "1608",
      local: "true"
    },
    { name: "RotCreatorAuthStateSize",
      desc: "Size of the ROT_CREATOR_AUTH_STATE partition",
      type: "int",
      default: "40",
      local: "true"
    },
    { name: "RotCreatorAuthStateEcdsaKey0Offset",
      desc: "Offset of ROT_CREATOR_AUTH_STATE_ECDSA_KEY0",
      type: "int",
      default: "1608",
      local: "true"
    },
    { name: "RotCreatorAuthStateEcdsaKey0Size",
      desc: "Size of ROT_CREATOR_AUTH_STATE_ECDSA_KEY0",
      type: "int",
      default: "4",
      local: "true"
    },
    { name: "RotCreatorAuthStateEcdsaKey1Offset",
      desc: "Offset of ROT_CREATOR_AUTH_STATE_ECDSA_KEY1",
      type: "int",
      default: "1612",
      local: "true"
    },
    { name: "RotCreatorAuthStateEcdsaKey1Size",
      desc: "Size of ROT_CREATOR_AUTH_STATE_ECDSA_KEY1",
      type: "int",
      default: "4",
      local: "true"
    },
    { name: "RotCreatorAuthStateEcdsaKey2Offset",
      desc: "Offset of ROT_CREATOR_AUTH_STATE_ECDSA_KEY2",
      type: "int",
      default: "1616",
      local: "true"
    },
    { name: "RotCreatorAuthStateEcdsaKey2Size",
      desc: "Size of ROT_CREATOR_AUTH_STATE_ECDSA_KEY2",
      type: "int",
      default: "4",
      local: "true"
    },
    { name: "RotCreatorAuthStateEcdsaKey3Offset",
      desc: "Offset of ROT_CREATOR_AUTH_STATE_ECDSA_KEY3",
      type: "int",
      default: "1620",
      local: "true"
    },
    { name: "RotCreatorAuthStateEcdsaKey3Size",
      desc: "Size of ROT_CREATOR_AUTH_STATE_ECDSA_KEY3",
      type: "int",
      default: "4",
      local: "true"
    },
    { name: "RotCreatorAuthStateSpxKey0Offset",
      desc: "Offset of ROT_CREATOR_AUTH_STATE_SPX_KEY0",
      type: "int",
      default: "1624",
      local: "true"
    },
    { name: "RotCreatorAuthStateSpxKey0Size",
      desc: "Size of ROT_CREATOR_AUTH_STATE_SPX_KEY0",
      type: "int",
      default: "4",
      local: "true"
    },
    { name: "RotCreatorAuthStateSpxKey1Offset",
      desc: "Offset of ROT_CREATOR_AUTH_STATE_SPX_KEY1",
      type: "int",
      default: "1628",
      local: "true"
    },
    { name: "RotCreatorAuthStateSpxKey1Size",
      desc: "Size of ROT_CREATOR_AUTH_STATE_SPX_KEY1",
      type: "int",
      default: "4",
      local: "true"
    },
    { name: "RotCreatorAuthStateSpxKey2Offset",
      desc: "Offset of ROT_CREATOR_AUTH_STATE_SPX_KEY2",
      type: "int",
      default: "1632",
      local: "true"
    },
    { name: "RotCreatorAuthStateSpxKey2Size",
      desc: "Size of ROT_CREATOR_AUTH_STATE_SPX_KEY2",
      type: "int",
      default: "4",
      local: "true"
    },
    { name: "RotCreatorAuthStateSpxKey3Offset",
      desc: "Offset of ROT_CREATOR_AUTH_STATE_SPX_KEY3",
      type: "int",
      default: "1636",
      local: "true"
    },
    { name: "RotCreatorAuthStateSpxKey3Size",
      desc: "Size of ROT_CREATOR_AUTH_STATE_SPX_KEY3",
      type: "int",
      default: "4",
      local: "true"
    },
    { name: "RotCreatorAuthStateDigestOffset",
      desc: "Offset of ROT_CREATOR_AUTH_STATE_DIGEST",
      type: "int",
      default: "1640",
      local: "true"
    },
    { name: "RotCreatorAuthStateDigestSize",
      desc: "Size of ROT_CREATOR_AUTH_STATE_DIGEST",
      type: "int",
      default: "8",
      local: "true"
    },
    { name: "HwCfg0Offset",
      desc: "Offset of the HW_CFG0 partition",
      type: "int",
      default: "1648",
      local: "true"
    },
    { name: "HwCfg0Size",
      desc: "Size of the HW_CFG0 partition",
      type: "int",
      default: "72",
      local: "true"
    },
    { name: "DeviceIdOffset",
      desc: "Offset of DEVICE_ID",
      type: "int",
      default: "1648",
      local: "true"
    },
    { name: "DeviceIdSize",
      desc: "Size of DEVICE_ID",
      type: "int",
      default: "32",
      local: "true"
    },
    { name: "ManufStateOffset",
      desc: "Offset of MANUF_STATE",
      type: "int",
      default: "1680",
      local: "true"
    },
    { name: "ManufStateSize",
      desc: "Size of MANUF_STATE",
      type: "int",
      default: "32",
      local: "true"
    },
    { name: "HwCfg0DigestOffset",
      desc: "Offset of HW_CFG0_DIGEST",
      type: "int",
      default: "1712",
      local: "true"
    },
    { name: "HwCfg0DigestSize",
      desc: "Size of HW_CFG0_DIGEST",
      type: "int",
      default: "8",
      local: "true"
    },
    { name: "HwCfg1Offset",
      desc: "Offset of the HW_CFG1 partition",
      type: "int",
      default: "1720",
      local: "true"
    },
    { name: "HwCfg1Size",
      desc: "Size of the HW_CFG1 partition",
      type: "int",
      default: "16",
      local: "true"
    },
    { name: "EnSramIfetchOffset",
      desc: "Offset of EN_SRAM_IFETCH",
      type: "int",
      default: "1720",
      local: "true"
    },
    { name: "EnSramIfetchSize",
      desc: "Size of EN_SRAM_IFETCH",
      type: "int",
      default: "1",
      local: "true"
    },
    { name: "DisRvDmLateDebugOffset",
      desc: "Offset of DIS_RV_DM_LATE_DEBUG",
      type: "int",
      default: "1721",
      local: "true"
    },
    { name: "DisRvDmLateDebugSize",
      desc: "Size of DIS_RV_DM_LATE_DEBUG",
      type: "int",
      default: "1",
      local: "true"
    },
    { name: "HwCfg1DigestOffset",
      desc: "Offset of HW_CFG1_DIGEST",
      type: "int",
      default: "1728",
      local: "true"
    },
    { name: "HwCfg1DigestSize",
      desc: "Size of HW_CFG1_DIGEST",
      type: "int",
      default: "8",
      local: "true"
    },
    { name: "Secret0Offset",
      desc: "Offset of the SECRET0 partition",
      type: "int",
      default: "1736",
      local: "true"
    },
    { name: "Secret0Size",
      desc: "Size of the SECRET0 partition",
      type: "int",
      default: "48",
      local: "true"
    },
    { name: "TestUnlockTokenOffset",
      desc: "Offset of TEST_UNLOCK_TOKEN",
      type: "int",
      default: "1736",
      local: "true"
    },
    { name: "TestUnlockTokenSize",
      desc: "Size of TEST_UNLOCK_TOKEN",
      type: "int",
      default: "16",
      local: "true"
    },
    { name: "TestExitTokenOffset",
      desc: "Offset of TEST_EXIT_TOKEN",
      type: "int",
      default: "1752",
      local: "true"
    },
    { name: "TestExitTokenSize",
      desc: "Size of TEST_EXIT_TOKEN",
      type: "int",
      default: "16",
      local: "true"
    },
    { name: "Secret0DigestOffset",
      desc: "Offset of SECRET0_DIGEST",
      type: "int",
      default: "1768",
      local: "true"
    },
    { name: "Secret0DigestSize",
      desc: "Size of SECRET0_DIGEST",
      type: "int",
      default: "8",
      local: "true"
    },
    { name: "Secret0ZerOffset",
      desc: "Offset of SECRET0_ZER",
      type: "int",
      default: "1776",
      local: "true"
    },
    { name: "Secret0ZerSize",
      desc: "Size of SECRET0_ZER",
      type: "int",
      default: "8",
      local: "true"
    },
    { name: "Secret1Offset",
      desc: "Offset of the SECRET1 partition",
      type: "int",
      default: "1784",
      local: "true"
    },
    { name: "Secret1Size",
      desc: "Size of the SECRET1 partition",
      type: "int",
      default: "96",
      local: "true"
    },
    { name: "NvmAddrKeySeedOffset",
      desc: "Offset of NVM_ADDR_KEY_SEED",
      type: "int",
      default: "1784",
      local: "true"
    },
    { name: "NvmAddrKeySeedSize",
      desc: "Size of NVM_ADDR_KEY_SEED",
      type: "int",
      default: "32",
      local: "true"
    },
    { name: "NvmDataKeySeedOffset",
      desc: "Offset of NVM_DATA_KEY_SEED",
      type: "int",
      default: "1816",
      local: "true"
    },
    { name: "NvmDataKeySeedSize",
      desc: "Size of NVM_DATA_KEY_SEED",
      type: "int",
      default: "32",
      local: "true"
    },
    { name: "SramDataKeySeedOffset",
      desc: "Offset of SRAM_DATA_KEY_SEED",
      type: "int",
      default: "1848",
      local: "true"
    },
    { name: "SramDataKeySeedSize",
      desc: "Size of SRAM_DATA_KEY_SEED",
      type: "int",
      default: "16",
      local: "true"
    },
    { name: "Secret1DigestOffset",
      desc: "Offset of SECRET1_DIGEST",
      type: "int",
      default: "1864",
      local: "true"
    },
    { name: "Secret1DigestSize",
      desc: "Size of SECRET1_DIGEST",
      type: "int",
      default: "8",
      local: "true"
    },
    { name: "Secret1ZerOffset",
      desc: "Offset of SECRET1_ZER",
      type: "int",
      default: "1872",
      local: "true"
    },
    { name: "Secret1ZerSize",
      desc: "Size of SECRET1_ZER",
      type: "int",
      default: "8",
      local: "true"
    },
    { name: "Secret2Offset",
      desc: "Offset of the SECRET2 partition",
      type: "int",
      default: "1880",
      local: "true"
    },
    { name: "Secret2Size",
      desc: "Size of the SECRET2 partition",
      type: "int",
      default: "128",
      local: "true"
    },
    { name: "RmaTokenOffset",
      desc: "Offset of RMA_TOKEN",
      type: "int",
      default: "1880",
      local: "true"
    },
    { name: "RmaTokenSize",
      desc: "Size of RMA_TOKEN",
      type: "int",
      default: "16",
      local: "true"
    },
    { name: "CreatorRootKeyShare0Offset",
      desc: "Offset of CREATOR_ROOT_KEY_SHARE0",
      type: "int",
      default: "1896",
      local: "true"
    },
    { name: "CreatorRootKeyShare0Size",
      desc: "Size of CREATOR_ROOT_KEY_SHARE0",
      type: "int",
      default: "48",
      local: "true"
    },
    { name: "CreatorRootKeyShare1Offset",
      desc: "Offset of CREATOR_ROOT_KEY_SHARE1",
      type: "int",
      default: "1944",
      local: "true"
    },
    { name: "CreatorRootKeyShare1Size",
      desc: "Size of CREATOR_ROOT_KEY_SHARE1",
      type: "int",
      default: "48",
      local: "true"
    },
    { name: "Secret2DigestOffset",
      desc: "Offset of SECRET2_DIGEST",
      type: "int",
      default: "1992",
      local: "true"
    },
    { name: "Secret2DigestSize",
      desc: "Size of SECRET2_DIGEST",
      type: "int",
      default: "8",
      local: "true"
    },
    { name: "Secret2ZerOffset",
      desc: "Offset of SECRET2_ZER",
      type: "int",
      default: "2000",
      local: "true"
    },
    { name: "Secret2ZerSize",
      desc: "Size of SECRET2_ZER",
      type: "int",
      default: "8",
      local: "true"
    },
    { name: "Secret3Offset",
      desc: "Offset of the SECRET3 partition",
      type: "int",
      default: "2008",
      local: "true"
    },
    { name: "Secret3Size",
      desc: "Size of the SECRET3 partition",
      type: "int",
      default: "144",
      local: "true"
    },
    { name: "FieldEntropyOffset",
      desc: "Offset of FIELD_ENTROPY",
      type: "int",
      default: "2008",
      local: "true"
    },
    { name: "FieldEntropySize",
      desc: "Size of FIELD_ENTROPY",
      type: "int",
      default: "32",
      local: "true"
    },
    { name: "SecondaryRootKeyShare0Offset",
      desc: "Offset of SECONDARY_ROOT_KEY_SHARE0",
      type: "int",
      default: "2040",
      local: "true"
    },
    { name: "SecondaryRootKeyShare0Size",
      desc: "Size of SECONDARY_ROOT_KEY_SHARE0",
      type: "int",
      default: "48",
      local: "true"
    },
    { name: "SecondaryRootKeyShare1Offset",
      desc: "Offset of SECONDARY_ROOT_KEY_SHARE1",
      type: "int",
      default: "2088",
      local: "true"
    },
    { name: "SecondaryRootKeyShare1Size",
      desc: "Size of SECONDARY_ROOT_KEY_SHARE1",
      type: "int",
      default: "48",
      local: "true"
    },
    { name: "Secret3DigestOffset",
      desc: "Offset of SECRET3_DIGEST",
      type: "int",
      default: "2136",
      local: "true"
    },
    { name: "Secret3DigestSize",
      desc: "Size of SECRET3_DIGEST",
      type: "int",
      default: "8",
      local: "true"
    },
    { name: "Secret3ZerOffset",
      desc: "Offset of SECRET3_ZER",
      type: "int",
      default: "2144",
      local: "true"
    },
    { name: "Secret3ZerSize",
      desc: "Size of SECRET3_ZER",
      type: "int",
      default: "8",
      local: "true"
    },
    { name: "LifeCycleOffset",
      desc: "Offset of the LIFE_CYCLE partition",
      type: "int",
      default: "2152",
      local: "true"
    },
    { name: "LifeCycleSize",
      desc: "Size of the LIFE_CYCLE partition",
      type: "int",
      default: "88",
      local: "true"
    },
    { name: "LcTransitionCntOffset",
      desc: "Offset of LC_TRANSITION_CNT",
      type: "int",
      default: "2152",
      local: "true"
    },
    { name: "LcTransitionCntSize",
      desc: "Size of LC_TRANSITION_CNT",
      type: "int",
      default: "48",
      local: "true"
    },
    { name: "LcStateOffset",
      desc: "Offset of LC_STATE",
      type: "int",
      default: "2200",
      local: "true"
    },
    { name: "LcStateSize",
      desc: "Size of LC_STATE",
      type: "int",
      default: "40",
      local: "true"
    },
  ]

  /////////////////////////////
  // Intermodule Connections //
  /////////////////////////////

  inter_signal_list: [
    // EDN interface
    { struct:  "edn"
      type:    "req_rsp"
      name:    "edn"
      act:     "req"
      package: "edn_pkg"
      desc:    "Entropy request to the entropy distribution network for LFSR reseeding and ephemeral key derivation."
    }
    // Power manager init command
    { struct:  "pwr_otp"
      type:    "req_rsp"
      name:    "pwr_otp"
      act:     "rsp"
      default: "'0"
      package: "pwrmgr_pkg"
      desc:    "Initialization request/acknowledge from/to power manager."
    }
    // LC transition command
    { struct:  "lc_otp_program"
      type:    "req_rsp"
      name:    "lc_otp_program"
      act:     "rsp"
      default: "'0"
      package: "otp_ctrl_pkg"
      desc:    "Life cycle state transition interface."
    }
    // Broadcast to LC
    { struct:  "otp_lc_data"
      type:    "uni"
      name:    "otp_lc_data"
      act:     "req"
      default: "'0"
      package: "otp_ctrl_pkg"
      desc:    '''
               Life cycle state output holding the current life cycle state,
               the value of the transition counter and the tokens needed for life cycle transitions.
               '''
    }
    // Broadcast from LC
    { struct:  "lc_tx"
      type:    "uni"
      name:    "lc_escalate_en"
      act:     "rcv"
      default: "lc_ctrl_pkg::Off"
      package: "lc_ctrl_pkg"
      desc:    '''
               Life cycle escalation enable coming from life cycle controller.
               This signal moves all FSMs within OTP into the error state.
               '''
    }
    { struct:  "lc_tx"
      type:    "uni"
      name:    "lc_creator_seed_sw_rw_en"
      act:     "rcv"
      default: "lc_ctrl_pkg::Off"
      package: "lc_ctrl_pkg"
      desc:    '''
               Provision enable qualifier coming from life cycle controller.
               This signal enables SW read / write access to the RMA_TOKEN and CREATOR_ROOT_KEY_SHARE0 and CREATOR_ROOT_KEY_SHARE1.
               '''
    }
    { struct:  "lc_tx"
      type:    "uni"
      name:    "lc_owner_seed_sw_rw_en"
      act:     "rcv"
      default: "lc_ctrl_pkg::Off"
      package: "lc_ctrl_pkg"
      desc:    '''
               Provision enable qualifier coming from life cycle controller.
               This signal enables SW read / write access to the OWNER_SEED.
               '''
    }
    { struct:  "lc_tx"
      type:    "uni"
      name:    "lc_seed_hw_rd_en"
      act:     "rcv"
      default: "lc_ctrl_pkg::Off"
      package: "lc_ctrl_pkg"
      desc:    '''
               Seed read enable coming from life cycle controller.
               This signal enables HW read access to the:
               - CREATOR_ROOT_KEY_SHARE0 and CREATOR_ROOT_KEY_SHARE1
               - SECONDARY_ROOT_KEY_SHARE0 and SECONDARY_ROOT_KEY_SHARE1
               - FIELD_ENTROPY
               '''
    }
    { struct:  "lc_tx"
      type:    "uni"
      name:    "lc_rma_state"
      act:     "rcv"
      default: "lc_ctrl_pkg::Off"
      package: "lc_ctrl_pkg"
      desc:    '''
               This signal states whether the current life cycle is RMA.
               It is used to enable SW read access to (read-locked) partitions in the RMA state.
               '''
    }
    { struct:  "lc_tx"
      type:    "uni"
      name:    "lc_check_byp_en"
      act:     "rcv"
      default: "lc_ctrl_pkg::Off"
      package: "lc_ctrl_pkg"
      desc:    '''
               Life cycle partition check bypass signal.
               This signal causes the life cycle partition to bypass consistency checks during life cycle state transitions in order to prevent spurious consistency check failures.
               '''
    }
    // Broadcast to Key Manager
    { struct:  "keymgr_dpe_creator_root_key"
      type:    "uni"
      name:    "keymgr_creator_root_key"
      act:     "req"
      default: "'0"
      package: "keymgr_dpe_pkg"
      desc:    "Key output to the key manager holding CREATOR_ROOT_KEY_SHARE0 and CREATOR_ROOT_KEY_SHARE1."
    }
    { struct:  "keymgr_dpe_creator_seed"
      type:    "uni"
      name:    "keymgr_creator_seed"
      act:     "req"
      default: "'0"
      package: "keymgr_dpe_pkg"
      desc:    "Creator seed output to the key manager"
    }
    { struct:  "keymgr_dpe_owner_seed"
      type:    "uni"
      name:    "keymgr_owner_seed"
      act:     "req"
      default: "'0"
      package: "keymgr_dpe_pkg"
      desc:    "Owner seed output to the key manager"
    }
    { struct:  "keymgr_dpe_field_entropy"
      type:    "uni"
      name:    "keymgr_field_entropy"
      act:     "req"
      default: "'0"
      package: "keymgr_dpe_pkg"
      desc:    "Field entropy output to the key manager holding FIELD_ENTROPY."
    }
    { struct:  "keymgr_dpe_creator_root_key"
      type:    "uni"
      name:    "keymgr_secondary_root_key"
      act:     "req"
      default: "'0"
      package: "keymgr_dpe_pkg"
      desc:    "Key output to the key manager holding SECONDARY_ROOT_KEY_SHARE0 and SECONDARY_ROOT_KEY_SHARE1."
    }
    // Broadcast to Nvm Controller
    { struct:  "nvm_otp_key"
      type:    "req_rsp"
      name:    "nvm_otp_key"
      act:     "rsp"
      default: "'0"
      package: "otp_ctrl_pkg"
      desc:    "Key derivation interface for NVM scrambling."
    }
    // Key request from SRAM scramblers
    { struct:  "sram_otp_key"
      width:   "5"
      type:    "req_rsp"
      name:    "sram_otp_key"
      act:     "rsp"
      default: "'0"
      package: "otp_ctrl_pkg"
      desc:    "Array with key derivation interfaces for SRAM scrambling devices."
    }
    // Key request from OTBN RAM Scrambler
    { struct:  "otbn_otp_key"
      type:    "req_rsp"
      name:    "otbn_otp_key"
      act:     "rsp"
      default: "'0"
      package: "otp_ctrl_pkg"
      desc:    "Key derivation interface for OTBN scrambling devices."
    }
    // Hardware config partition
    { struct:  "otp_broadcast"
      type:    "uni"
      name:    "otp_broadcast"
      act:     "req"
      default: "'0"
      package: "otp_ctrl_part_pkg"
      desc:    "Output of the HW partitions with breakout data types."
    }
    // OTP_MACRO Interface
    { struct:  "otp_ctrl_macro"
      type:    "req_rsp"
      name:    "otp_macro"
      act:     "req"
      default: "'0"
      package: "otp_ctrl_macro_pkg"
      desc:    "Data interface for the OTP macro."
    }
  ] // inter_signal_list

  /////////////////////
  // Countermeasures //
  /////////////////////

  countermeasures: [
    { name: "BUS.INTEGRITY",
      desc: "End-to-end bus integrity scheme."
    }
    { name: "SECRET.MEM.SCRAMBLE",
      desc: "Secret partitions are scrambled with a full-round PRESENT cipher."
    }
    { name: "PART.MEM.DIGEST",
      desc: "Integrity of buffered partitions is ensured via a 64bit digest."
    }
    { name: "DAI.FSM.SPARSE",
      desc: "The direct access interface FSM is sparsely encoded."
    }
    { name: "KDI.FSM.SPARSE",
      desc: "The key derivation interface FSM is sparsely encoded."
    }
    { name: "LCI.FSM.SPARSE",
      desc: "The life cycle interface FSM is sparsely encoded."
    }
    { name: "PART.FSM.SPARSE",
      desc: "The partition FSMs are sparsely encoded."
    }
    { name: "SCRMBL.FSM.SPARSE",
      desc: "The scramble datapath FSM is sparsely encoded."
    }
    { name: "TIMER.FSM.SPARSE",
      desc: "The background check timer FSM is sparsely encoded."
    }
    { name: "DAI.CTR.REDUN",
      desc: "The direct access interface address counter employs a cross-counter implementation."
    }
    { name: "KDI_SEED.CTR.REDUN",
      desc: "The key derivation interface counter employs a cross-counter implementation."
    }
    { name: "KDI_ENTROPY.CTR.REDUN",
      desc: "The key derivation entropy counter employs a cross-counter implementation."
    }
    { name: "LCI.CTR.REDUN",
      desc: "The life cycle interface address counter employs a cross-counter implementation."
    }
    { name: "PART.CTR.REDUN",
      desc: "The address counter of buffered partitions employs a cross-counter implementation."
    }
    { name: "SCRMBL.CTR.REDUN",
      desc: "The srambling datapath counter employs a cross-counter implementation."
    }
    { name: "TIMER_INTEG.CTR.REDUN",
      desc: "The background integrity check timer employs a duplicated counter implementation."
    }
    { name: "TIMER_CNSTY.CTR.REDUN",
      desc: "The background consistency check timer employs a duplicated counter implementation."
    }
    { name: "TIMER.LFSR.REDUN",
      desc: "The background check LFSR is duplicated."
    }
    { name: "DAI.FSM.LOCAL_ESC",
      desc: "The direct access interface FSM is moved into an invalid state upon local escalation."
    }
    { name: "LCI.FSM.LOCAL_ESC",
      desc: "The life cycle interface FSM is moved into an invalid state upon local escalation."
    }
    { name: "KDI.FSM.LOCAL_ESC",
      desc: "The key derivation interface FSM is moved into an invalid state upon local escalation."
    }
    { name: "PART.FSM.LOCAL_ESC",
      desc: "The partition FSMs are moved into an invalid state upon local escalation."
    }
    { name: "SCRMBL.FSM.LOCAL_ESC",
      desc: "The scramble datapath FSM is moved into an invalid state upon local escalation."
    }
    { name: "TIMER.FSM.LOCAL_ESC",
      desc: "The background check timer FSM is moved into an invalid state upon local escalation."
    }
    { name: "DAI.FSM.GLOBAL_ESC",
      desc: "The direct access interface FSM is moved into an invalid state upon global escalation via life cycle."
    }
    { name: "LCI.FSM.GLOBAL_ESC",
      desc: "The life cycle interface FSM is moved into an invalid state upon global escalation via life cycle."
    }
    { name: "KDI.FSM.GLOBAL_ESC",
      desc: "The key derivation interface FSM is moved into an invalid state upon global escalation via life cycle."
    }
    { name: "PART.FSM.GLOBAL_ESC",
      desc: "The partition FSMs are moved into an invalid state upon global escalation via life cycle."
    }
    { name: "SCRMBL.FSM.GLOBAL_ESC",
      desc: "The scramble datapath FSM is moved into an invalid state upon global escalation via life cycle."
    }
    { name: "TIMER.FSM.GLOBAL_ESC",
      desc: "The background check timer FSM is moved into an invalid state upon global escalation via life cycle."
    }
    { name: "PART.DATA_REG.INTEGRITY",
      desc: "All partition buffer registers are protected with ECC on 64bit blocks."
    }
    { name: "PART.DATA_REG.BKGN_CHK",
      desc: "The digest of buffered partitions is recomputed and checked at pseudorandom intervals in the background."
    }
    { name: "PART.MEM.REGREN"
      desc: "Unbuffered ('software') partitions can be read-locked via a CSR until the next system reset."
    }
    { name: "PART.MEM.SW_UNREADABLE"
      desc: "Secret buffered partitions become unreadable to software once they are locked via the digest."
    }
    { name: "PART.MEM.SW_UNWRITABLE"
      desc: "All partitions become unwritable by software once they are locked via the digest."
    }
    { name: "LC_PART.MEM.SW_NOACCESS"
      desc: "The life cycle partition is not directly readable nor writable via software."
    }
    { name: "ACCESS.CTRL.MUBI",
      desc: "The access control signals going from the partitions to the DAI are MUBI encoded."
    }
    { name: "TOKEN_VALID.CTRL.MUBI",
      desc: "The token valid signals going to the life cycle controller are MUBI encoded."
    }
    { name: "LC_CTRL.INTERSIG.MUBI",
      desc: "The life cycle control signals are multibit encoded."
    }
    { name: "DIRECT_ACCESS.CONFIG.REGWEN",
      desc: "The direct access CSRs are REGWEN protected."
    }
    { name: "CHECK_TRIGGER.CONFIG.REGWEN",
      desc: "The check trigger CSR is REGWEN protected."
    }
    { name: "CHECK.CONFIG.REGWEN",
      desc: "The check CSR is REGWEN protected."
    }
  ]

  features: [
    {
      name: "OTP_CTRL.PARTITION.VENDOR_TEST"
      desc: '''Vendor test partition is used for OTP programming smoke check during manufacturing flow.
      In this partition, ECC uncorrectable errors will not lead to fatal errors and alerts.
      Instead the error will be reported as correctable ECC error.
      '''
    }
    {
      name: "OTP_CTRL.PARTITION.CREATOR_SW_CFG"
      desc: '''During calibration stage, various parameters (clock, voltage, and timing sources) are calibrated and recorded to CREATOR_SW_CFG partition.
      '''
    }
    {
      name: "OTP_CTRL.PARTITION.OWNER_SW_CFG"
      desc: "Define attributes for rom code execution"
    }
    {
      name: "OTP_CTRL.INIT"
      desc: '''When power is up, OTP controller reads devices status.
      After all reads complete, the controller performs integrity check on the HW_CFG* and SECRET partitions.
      Once all integrity checks are complete, the controller marks outputs as valid.
      '''
    }
    {
      name: "OTP_CTRL.ENTROPY_READ"
      desc: "Firmware can read entropy from ENTROPY_SRC block."
    }
    {
      name: "OTP_CTRL.KEY_DERIVATION"
      desc: "OTP controller participate key derivation process by providing scramble key seed to SRAM_CTRL and FLASH_CTRL."
    }
    {
      name: "OTP_CTRL.PROGRAM"
      desc: '''All other partitions except life cycle partition are programmed through DAI interface.
      And once non-zero digest is programmed to these partition, no further write access is allowed.
      Life cycle partition is programmed by LC_CTRL.
      '''
    }
    {
      name: "OTP_CTRL.PARTITION.SECRET0"
      desc: "Test unlock tokens, Test exit token"
    }
    {
      name: "OTP_CTRL.PARTITION.SECRET1"
      desc: "SRAM and NVM scrambling key"
    }
    {
      name: "OTP_CTRL.PARTITION.SECRET2"
      desc: "RMA unlock token and creator root key"
    }
    {
      name: "OTP_CTRL.PARTITION.LIFE_CYCLE"
      desc: '''LC state, LC transition count.
      This feature is owned by the LC_CTRL and cannot be tested well through the OTP_CTRL CSR interface.
      '''
    }
    {
      name: "OTP_CTRL.PARTITIONS_FEATURE.READ_LOCK"
      desc: '''Following partitions can be read lockable by CSR.
                 - VENDOR_TEST
                 - CREATOR_SW_CFG
                 - OWNER_SW_CFG
               Following partitions can be read lockable by writing digest.
                 - SECRET0
                 - SECRET1
                 - RECRET2
      All read attempt to these partitions after read is locked will trigger AccessError (recoverable).
      '''
    }
    {
      name: "OTP_CTRL.PARTITIONS_FEATURE.WRITE_LOCK"
      desc: "All partitions except LIFE_CYCLE can be write lockable by writing digest."
    }
    {
      name: "OTP_CTRL.ERROR_HANDLING.RECOVERABLE"
      desc: "Recoverable error is created when unauthorized access attempt are detected via dai interface."
    }
    {
      name: "OTP_CTRL.ERROR_HANDLING.FATAL"
      desc: "Unrecoverable errors are created for uncorrectable ecc error, otp macro malfunction and unauthorized access via lc_ctrl."
    }
    {
      name: "OTP_CTRL.BACKGROUND_CHECK.CHECK_TIMEOUT"
      desc: "Timeout value for the integrity and consistency checks."
    }
    {
      name: "OTP_CTRL.BACKGROUND_CHECK.INTEGRITY_CHECK_PERIOD"
      desc: "The interval which the digest of the partition is recomputed to check integrity of locked partition."
    }
    {
      name: "OTP_CTRL.BACKGROUND_CHECK.CONSISTENCY_CHECK_PERIOD"
      desc: "Re-read period of the buffer registers to ensure data is matched with the associated OTP partition."
    }
  ]

  ///////////////
  // Registers //
  ///////////////

  regwidth: "32",
  registers: {
    core: [
      ////////////////////////
      // Ctrl / Status CSRs //
      ////////////////////////

      { name: "STATUS",
        desc: "OTP status register.",
        swaccess: "ro",
        hwaccess: "hwo",
        hwext:    "true",
        resval:   0,
        tags: [ // OTP internal HW can modify status register
                "excl:CsrAllTests:CsrExclCheck"],
        fields: [
          { bits: "0"
            name: "PARTITION_ERROR"
            desc: '''
                  Set to 1 if an error occurred in any partition.
                  If set to 1, SW should check the !!PARTITION_STATUS register to determine the failing partition.
                  '''
          }
          { bits: "1"
            name: "DAI_ERROR"
            desc: '''
                  Set to 1 if an error occurred in the DAI.
                  If set to 1, SW should check the !!ERR_CODE register at the corresponding index.
                  '''
          }
          { bits: "2"
            name: "LCI_ERROR"
            desc: '''
                  Set to 1 if an error occurred in the LCI.
                  If set to 1, SW should check the !!ERR_CODE register at the corresponding index.
                  '''
          }
          { bits: "3"
            name: "TIMEOUT_ERROR"
            desc: '''
                  Set to 1 if an integrity or consistency check times out.
                  This raises an fatal_check_error alert and is an unrecoverable error condition.
                  '''
          }
          { bits: "4"
            name: "LFSR_FSM_ERROR"
            desc: '''
                  Set to 1 if the LFSR timer FSM has reached an invalid state.
                  This raises an fatal_check_error alert and is an unrecoverable error condition.
                  '''
          }
          { bits: "5"
            name: "SCRAMBLING_FSM_ERROR"
            desc: '''
                  Set to 1 if the scrambling datapath FSM has reached an invalid state.
                  This raises an fatal_check_error alert and is an unrecoverable error condition.
                  '''
          }
          { bits: "6"
            name: "KEY_DERIV_FSM_ERROR"
            desc: '''
                  Set to 1 if the key derivation FSM has reached an invalid state.
                  This raises an fatal_check_error alert and is an unrecoverable error condition.
                  '''
          }
          { bits: "7"
            name: "BUS_INTEG_ERROR"
            desc: '''
                  This bit is set to 1 if a fatal bus integrity fault is detected.
                  This error triggers a fatal_bus_integ_error alert.
                  '''
          }
          { bits: "8"
            name: "DAI_IDLE"
            desc: "Set to 1 if the DAI is idle and ready to accept commands."
          }
          { bits: "9"
            name: "CHECK_PENDING"
            desc: "Set to 1 if an integrity or consistency check triggered by the LFSR timer or via !!CHECK_TRIGGER is pending."
          }
        ]
      }
      { name: "PARTITION_STATUS_0",
        desc: "OTP partition status register 0.",
        swaccess: "ro",
        hwaccess: "hwo",
        hwext:    "true",
        resval:   0,
        tags: [ // OTP internal HW can modify status register
                "excl:CsrAllTests:CsrExclCheck"],
        fields: [
          { bits: "0"
            name: "VENDOR_TEST_ERROR"
            desc: '''
                  Set to 1 if an error occurred in this partition.
                  If set to 1, SW should check the !!ERR_CODE register at the corresponding index.
                  '''
          }
          { bits: "1"
            name: "CREATOR_SW_CFG_ERROR"
            desc: '''
                  Set to 1 if an error occurred in this partition.
                  If set to 1, SW should check the !!ERR_CODE register at the corresponding index.
                  '''
          }
          { bits: "2"
            name: "OWNER_SW_CFG_ERROR"
            desc: '''
                  Set to 1 if an error occurred in this partition.
                  If set to 1, SW should check the !!ERR_CODE register at the corresponding index.
                  '''
          }
          { bits: "3"
            name: "ROT_CREATOR_AUTH_CODESIGN_ERROR"
            desc: '''
                  Set to 1 if an error occurred in this partition.
                  If set to 1, SW should check the !!ERR_CODE register at the corresponding index.
                  '''
          }
          { bits: "4"
            name: "ROT_CREATOR_AUTH_STATE_ERROR"
            desc: '''
                  Set to 1 if an error occurred in this partition.
                  If set to 1, SW should check the !!ERR_CODE register at the corresponding index.
                  '''
          }
          { bits: "5"
            name: "HW_CFG0_ERROR"
            desc: '''
                  Set to 1 if an error occurred in this partition.
                  If set to 1, SW should check the !!ERR_CODE register at the corresponding index.
                  '''
          }
          { bits: "6"
            name: "HW_CFG1_ERROR"
            desc: '''
                  Set to 1 if an error occurred in this partition.
                  If set to 1, SW should check the !!ERR_CODE register at the corresponding index.
                  '''
          }
          { bits: "7"
            name: "SECRET0_ERROR"
            desc: '''
                  Set to 1 if an error occurred in this partition.
                  If set to 1, SW should check the !!ERR_CODE register at the corresponding index.
                  '''
          }
          { bits: "8"
            name: "SECRET1_ERROR"
            desc: '''
                  Set to 1 if an error occurred in this partition.
                  If set to 1, SW should check the !!ERR_CODE register at the corresponding index.
                  '''
          }
          { bits: "9"
            name: "SECRET2_ERROR"
            desc: '''
                  Set to 1 if an error occurred in this partition.
                  If set to 1, SW should check the !!ERR_CODE register at the corresponding index.
                  '''
          }
          { bits: "10"
            name: "SECRET3_ERROR"
            desc: '''
                  Set to 1 if an error occurred in this partition.
                  If set to 1, SW should check the !!ERR_CODE register at the corresponding index.
                  '''
          }
          { bits: "11"
            name: "LIFE_CYCLE_ERROR"
            desc: '''
                  Set to 1 if an error occurred in this partition.
                  If set to 1, SW should check the !!ERR_CODE register at the corresponding index.
                  '''
          }
        ]
      }
      { multireg: {
          name:     "ERR_CODE",
          desc:     '''
                    This register holds information about error conditions that occurred in the agents
                    interacting with the OTP macro via the internal bus. The error codes should be checked
                    if the partitions, DAI or LCI flag an error in the !!STATUS register, or when an
                    !!INTR_STATE.otp_error has been triggered. Note that all errors trigger an otp_error
                    interrupt, and in addition some errors may trigger either an fatal_macro_error or an
                    fatal_check_error alert.
                    ''',
          count:     "NumErrorEntries",
          swaccess:  "ro",
          hwaccess:  "hwo",
          hwext:     "true",
          cname:     "AGENT",
          compact:   "false",
          resval:    0,
          tags: [ // OTP internal HW can modify the error code registers
                  "excl:CsrAllTests:CsrExclCheck"],
          fields: [
            {
              bits: "2:0"
              enum: [
                { value: "0",
                  name: "NO_ERROR",
                  desc: '''
                  No error condition has occurred.
                  '''
                },
                { value: "1",
                  name: "MACRO_ERROR",
                  desc: '''
                  Returned if the OTP macro command was invalid or did not complete successfully
                  due to a macro malfunction.
                  This error should never occur during normal operation and is not recoverable.
                  This error triggers an fatal_macro_error alert.
                  '''
                },
                { value: "2",
                  name: "MACRO_ECC_CORR_ERROR",
                  desc: '''
                  A correctable ECC error has occurred during an OTP read operation.
                  The corresponding controller automatically recovers from this error when
                  issuing a new command.
                  '''
                },
                { value: "3",
                  name: "MACRO_ECC_UNCORR_ERROR",
                  desc: '''
                  An uncorrectable ECC error has occurred during an OTP read operation.
                  This error should never occur during normal operation and is not recoverable.
                  If this error is present this may be a sign that the device is malfunctioning.
                  This error triggers an fatal_macro_error alert.
                  '''
                },
                { value: "4",
                  name: "MACRO_WRITE_BLANK_ERROR",
                  desc: '''
                  This error is returned if a programming operation attempted to clear a bit that has previously been programmed to 1.
                  The corresponding controller automatically recovers from this error when issuing a new command.

                  Note however that the affected OTP word may be left in an inconsistent state if this error occurs.
                  This can cause several issues when the word is accessed again (either as part of a regular read operation, as part of the readout at boot, or as part of a background check).

                  It is important that SW ensures that each word is only written once, since this can render the device useless.
                  '''
                },
                { value: "5",
                  name: "ACCESS_ERROR",
                  desc: '''
                  This error indicates that a locked memory region has been accessed.
                  The corresponding controller automatically recovers from this error when issuing a new command.
                  '''
                },
                { value: "6",
                  name: "CHECK_FAIL_ERROR",
                  desc: '''
                  An ECC, integrity or consistency mismatch has been detected in the buffer registers.
                  This error should never occur during normal operation and is not recoverable.
                  This error triggers an fatal_check_error alert.
                  '''
                },
                { value: "7",
                  name: "FSM_STATE_ERROR",
                  desc: '''
                  The FSM of the corresponding controller has reached an invalid state, or the FSM has
                  been moved into a terminal error state due to an escalation action via lc_escalate_en_i.
                  This error should never occur during normal operation and is not recoverable.
                  If this error is present, this is a sign that the device has fallen victim to
                  an invasive attack. This error triggers an fatal_check_error alert.
                  '''
                },
              ]
            }
          ]
        }
      }
      { name: "DIRECT_ACCESS_REGWEN",
        desc: '''
              Register write enable for all direct access interface registers.
              ''',
        swaccess: "rw0c",
        hwaccess: "hrw",
        hwext:    "true",
        hwqe:     "true",
        tags: [ // OTP internal HW will set this enable register to 0 when OTP is not under IDLE
                // state, so could not auto-predict its value
                "excl:CsrNonInitTests:CsrExclCheck"],
        fields: [
          {
              bits:   "0",
              desc: '''
              This bit controls whether the DAI registers can be written.
              Write 0 to it in order to clear the bit.

              Note that the hardware also modulates this bit and sets it to 0 temporarily
              during an OTP operation such that the corresponding address and data registers
              cannot be modified while an operation is pending. The !!DAI_IDLE status bit
              will also be set to 0 in such a case.
              '''
              resval: 1,
          },
        ]
      },
      { name: "DIRECT_ACCESS_CMD",
        desc: "Command register for direct accesses.",
        swaccess: "r0w1c",
        hwaccess: "hro",
        hwqe:     "true",
        hwext:    "true",
        resval:   0,
        regwen:   "DIRECT_ACCESS_REGWEN",
        tags: [ // Write to DIRECT_ACCESS_CMD randomly might cause OTP_ERRORs and illegal sequences
                "excl:CsrNonInitTests:CsrExclWrite"],
        fields: [
          { bits: "0",
            name: "RD",
            desc: '''
            Initiates a readout sequence that reads the location specified
            by !!DIRECT_ACCESS_ADDRESS. The command places the data read into
            !!DIRECT_ACCESS_RDATA_0 and !!DIRECT_ACCESS_RDATA_1 (for 64bit partitions).
            '''
          }
          { bits: "1",
            name: "WR",
            desc: '''
                  Initiates a programming sequence that writes the data in !!DIRECT_ACCESS_WDATA_0
                  and !!DIRECT_ACCESS_WDATA_1 (for 64bit partitions) to the location specified by
                  !!DIRECT_ACCESS_ADDRESS.
                  '''
          }
          { bits: "2",
            name: "DIGEST",
            desc: '''
                  Initiates the digest calculation and locking sequence for the partition specified by
                  !!DIRECT_ACCESS_ADDRESS.
                  '''
          }
          { bits: "3",
            name: "ZEROIZE",
            desc: '''
                  Initiates the zeroization sequence of location specified by !!DIRECT_ACCESS_ADDRESS.
                  The command places the zeroized data into !!DIRECT_ACCESS_RDATA_0 and
                  !!DIRECT_ACCESS_RDATA_1 (for 64bit partitions) if the execution is successful.
                  '''
          }
        ]
      }
      { name: "DIRECT_ACCESS_ADDRESS",
        desc: "Address register for direct accesses.",
        swaccess: "rw",
        hwaccess: "hro",
        hwqe:     "false",
        resval:   0,
        regwen:   "DIRECT_ACCESS_REGWEN",
        tags: [ // The enable register "DIRECT_ACCESS_REGWEN" is HW controlled,
                // so not able to predict this register value automatically
                "excl:CsrNonInitTests:CsrExclCheck"],
        fields: [
          { bits: "OtpByteAddrWidth-1:0",
            desc: '''
                  This is the address for the OTP word to be read or written through
                  the direct access interface. Note that the address is aligned to the access size
                  internally, hence bits 1:0 are ignored for 32bit accesses, and bits 2:0 are ignored
                  for 64bit accesses.

                  For the digest calculation command, set this register to the partition base offset.
                  '''
          }
        ]
      }
      { multireg: {
          name:     "DIRECT_ACCESS_WDATA",
          desc:     '''Write data for direct accesses.
                    Hardware automatically determines the access granule (32bit or 64bit) based on which
                    partition is being written to.
                    ''',
          count:    "NumDaiWords", // 2 x 32bit = 64bit
          swaccess: "rw",
          hwaccess: "hro",
          hwqe:     "false",
          regwen:   "DIRECT_ACCESS_REGWEN",
          cname:    "WORD",
          resval:   0,
          tags: [ // The value of this register is written from "DIRECT_ACCESS_RDATA",
                  // so could not predict this register value automatically
                  "excl:CsrAllTests:CsrExclCheck"],
          fields: [
            { bits: "31:0"
            }
          ]
        }
      },
      { multireg: {
          name:     "DIRECT_ACCESS_RDATA",
          desc:     '''Read data for direct accesses.
                    Hardware automatically determines the access granule (32bit or 64bit) based on which
                    partition is read from.
                    ''',
          count:    "NumDaiWords", // 2 x 32bit = 64bit
          swaccess: "ro",
          hwaccess: "hwo",
          hwext:    "true",
          cname:    "WORD",
          resval:   0,
          fields: [
            { bits: "31:0"
            }
          ]
        }
      },

      //////////////////////////////////////
      // Integrity and Consistency Checks //
      //////////////////////////////////////
      { name: "CHECK_TRIGGER_REGWEN",
        desc: '''
              Register write enable for !!CHECK_TRIGGER.
              ''',
        swaccess: "rw0c",
        hwaccess: "none",
        fields: [
          { bits:   "0",
            desc: '''
            When cleared to 0, the !!CHECK_TRIGGER register cannot be written anymore.
            Write 0 to clear this bit.
            '''
            resval: 1,
          },
        ]
      },
      { name: "CHECK_TRIGGER",
        desc: "Command register for direct accesses.",
        swaccess: "r0w1c",
        hwaccess: "hro",
        hwqe:     "true",
        hwext:    "true",
        resval:   0,
        regwen:   "CHECK_TRIGGER_REGWEN",
        fields: [
          { bits: "0",
            name: "INTEGRITY",
            desc: '''
            Writing 1 to this bit triggers an integrity check. SW should monitor !!STATUS.CHECK_PENDING
            and wait until the check has been completed. If there are any errors, those will be flagged
            in the !!STATUS and !!ERR_CODE registers, and via the interrupts and alerts.
            '''
          }
          { bits: "1",
            name: "CONSISTENCY",
            desc: '''
            Writing 1 to this bit triggers a consistency check. SW should monitor !!STATUS.CHECK_PENDING
            and wait until the check has been completed. If there are any errors, those will be flagged
            in the !!STATUS and !!ERR_CODE registers, and via interrupts and alerts.
            '''
          }
        ]
      },
      { name: "CHECK_REGWEN",
        desc: '''
              Register write enable for !!INTEGRITY_CHECK_PERIOD and !!CONSISTENCY_CHECK_PERIOD.
              ''',
        swaccess: "rw0c",
        hwaccess: "none",
        fields: [
          { bits:   "0",
            desc: '''
            When cleared to 0, !!INTEGRITY_CHECK_PERIOD and !!CONSISTENCY_CHECK_PERIOD registers cannot be written anymore.
            Write 0 to clear this bit.
            '''
            resval: 1,
          },
        ]
      },
      { name: "CHECK_TIMEOUT",
        desc: '''
              Timeout value for the integrity and consistency checks.
              ''',
        swaccess: "rw",
        hwaccess: "hro",
        regwen:   "CHECK_REGWEN",
        tags: [ // Do not write to this automatically, as it may trigger fatal alert, and cause
                // escalation.
                "excl:CsrAllTests:CsrExclWrite"],
        fields: [
          { bits: "31:0",
            desc: '''
            Timeout value in cycles for the for the integrity and consistency checks. If an integrity or consistency
            check does not complete within the timeout window, an error will be flagged in the !!STATUS register,
            an otp_error interrupt will be raised, and an fatal_check_error alert will be sent out. The timeout should
            be set to a large value to stay on the safe side. The maximum check time can be upper bounded by the
            number of cycles it takes to readout, scramble and digest the entire OTP array. Since this amounts to
            roughly 25k cycles, it is recommended to set this value to at least 100'000 cycles in order to stay on the
            safe side. A value of zero disables the timeout mechanism (default).
            '''
            resval: 0,
          },
        ]
      },
      { name: "INTEGRITY_CHECK_PERIOD",
        desc: '''
              This value specifies the maximum period that can be generated pseudo-randomly.
              Only applies to the HW_CFG* and SECRET* partitions once they are locked.
              '''
        swaccess: "rw",
        hwaccess: "hro",
        regwen:   "CHECK_REGWEN",
        fields: [
          { bits: "31:0",
            desc: '''
            The pseudo-random period is generated using a 40bit LFSR internally, and this register defines
            the bit mask to be applied to the LFSR output in order to limit its range. The value of this
            register is left shifted by 8bits and the lower bits are set to 8'hFF in order to form the 40bit mask.
            A recommended value is 0x3_FFFF, corresponding to a maximum period of ~2.8s at 24MHz.
            A value of zero disables the timer (default). Note that a one-off check can always be triggered via
            !!CHECK_TRIGGER.INTEGRITY.
            '''
            resval: "0"
          }
        ]
      }
      { name: "CONSISTENCY_CHECK_PERIOD",
        desc: '''
              This value specifies the maximum period that can be generated pseudo-randomly.
              This applies to the LIFE_CYCLE partition and the HW_CFG* and SECRET* partitions once they are locked.
              '''
        swaccess: "rw",
        hwaccess: "hro",
        regwen:   "CHECK_REGWEN",
        fields: [
          { bits: "31:0",
            desc: '''
            The pseudo-random period is generated using a 40bit LFSR internally, and this register defines
            the bit mask to be applied to the LFSR output in order to limit its range. The value of this
            register is left shifted by 8bits and the lower bits are set to 8'hFF in order to form the 40bit mask.
            A recommended value is 0x3FF_FFFF, corresponding to a maximum period of ~716s at 24MHz.
            A value of zero disables the timer (default). Note that a one-off check can always be triggered via
            !!CHECK_TRIGGER.CONSISTENCY.
            '''
            resval: "0"
          }
        ]
      }

      ////////////////////////////////////
      // Dynamic Locks of SW Parititons //
      ////////////////////////////////////
      { name: "VENDOR_TEST_READ_LOCK",
        desc: '''
              Runtime read lock for the VENDOR_TEST partition.
              ''',
        swaccess: "rw0c",
        hwaccess: "hro",
        regwen:   "DIRECT_ACCESS_REGWEN",
        tags:     [ // The value of this register can affect the read access of the this
                    // partition's memory window. Excluding this register from writing can ensure
                    // memories have read and write access.
                    "excl:CsrNonInitTests:CsrExclWrite"],
        fields: [
          { bits:   "0",
            desc: '''
            When cleared to 0, read access to the VENDOR_TEST partition is locked.
            Write 0 to clear this bit.
            '''
            resval: 1,
          },
        ]
      },
      { name: "CREATOR_SW_CFG_READ_LOCK",
        desc: '''
              Runtime read lock for the CREATOR_SW_CFG partition.
              ''',
        swaccess: "rw0c",
        hwaccess: "hro",
        regwen:   "DIRECT_ACCESS_REGWEN",
        tags:     [ // The value of this register can affect the read access of the this
                    // partition's memory window. Excluding this register from writing can ensure
                    // memories have read and write access.
                    "excl:CsrNonInitTests:CsrExclWrite"],
        fields: [
          { bits:   "0",
            desc: '''
            When cleared to 0, read access to the CREATOR_SW_CFG partition is locked.
            Write 0 to clear this bit.
            '''
            resval: 1,
          },
        ]
      },
      { name: "OWNER_SW_CFG_READ_LOCK",
        desc: '''
              Runtime read lock for the OWNER_SW_CFG partition.
              ''',
        swaccess: "rw0c",
        hwaccess: "hro",
        regwen:   "DIRECT_ACCESS_REGWEN",
        tags:     [ // The value of this register can affect the read access of the this
                    // partition's memory window. Excluding this register from writing can ensure
                    // memories have read and write access.
                    "excl:CsrNonInitTests:CsrExclWrite"],
        fields: [
          { bits:   "0",
            desc: '''
            When cleared to 0, read access to the OWNER_SW_CFG partition is locked.
            Write 0 to clear this bit.
            '''
            resval: 1,
          },
        ]
      },
      { name: "ROT_CREATOR_AUTH_CODESIGN_READ_LOCK",
        desc: '''
              Runtime read lock for the ROT_CREATOR_AUTH_CODESIGN partition.
              ''',
        swaccess: "rw0c",
        hwaccess: "hro",
        regwen:   "DIRECT_ACCESS_REGWEN",
        tags:     [ // The value of this register can affect the read access of the this
                    // partition's memory window. Excluding this register from writing can ensure
                    // memories have read and write access.
                    "excl:CsrNonInitTests:CsrExclWrite"],
        fields: [
          { bits:   "0",
            desc: '''
            When cleared to 0, read access to the ROT_CREATOR_AUTH_CODESIGN partition is locked.
            Write 0 to clear this bit.
            '''
            resval: 1,
          },
        ]
      },
      { name: "ROT_CREATOR_AUTH_STATE_READ_LOCK",
        desc: '''
              Runtime read lock for the ROT_CREATOR_AUTH_STATE partition.
              ''',
        swaccess: "rw0c",
        hwaccess: "hro",
        regwen:   "DIRECT_ACCESS_REGWEN",
        tags:     [ // The value of this register can affect the read access of the this
                    // partition's memory window. Excluding this register from writing can ensure
                    // memories have read and write access.
                    "excl:CsrNonInitTests:CsrExclWrite"],
        fields: [
          { bits:   "0",
            desc: '''
            When cleared to 0, read access to the ROT_CREATOR_AUTH_STATE partition is locked.
            Write 0 to clear this bit.
            '''
            resval: 1,
          },
        ]
      },

      ///////////////////////
      // Integrity Digests //
      ///////////////////////
      { multireg: {
          name:     "VENDOR_TEST_DIGEST",
          desc:     '''
                    Integrity digest for the VENDOR_TEST partition.
                    The integrity digest is 0 by default. Software must write a non-zero
                    digest value via the direct access interface in order to lock the partition.
                    After a reset, write access to the VENDOR_TEST partition is locked and
                    the digest becomes visible in this CSR.
                    ''',
          count:     "NumDigestWords",
          swaccess:  "ro",
          hwaccess:  "hwo",
          hwext:     "true",
          cname:     "WORD",
          resval:    0,
          tags: [ // OTP internal HW will update status so can not auto-predict its value.
                  "excl:CsrAllTests:CsrExclCheck"],
          fields: [
            { bits: "31:0"
            }
          ]
        }
      },
      { multireg: {
          name:     "CREATOR_SW_CFG_DIGEST",
          desc:     '''
                    Integrity digest for the CREATOR_SW_CFG partition.
                    The integrity digest is 0 by default. Software must write a non-zero
                    digest value via the direct access interface in order to lock the partition.
                    After a reset, write access to the CREATOR_SW_CFG partition is locked and
                    the digest becomes visible in this CSR.
                    ''',
          count:     "NumDigestWords",
          swaccess:  "ro",
          hwaccess:  "hwo",
          hwext:     "true",
          cname:     "WORD",
          resval:    0,
          tags: [ // OTP internal HW will update status so can not auto-predict its value.
                  "excl:CsrAllTests:CsrExclCheck"],
          fields: [
            { bits: "31:0"
            }
          ]
        }
      },
      { multireg: {
          name:     "OWNER_SW_CFG_DIGEST",
          desc:     '''
                    Integrity digest for the OWNER_SW_CFG partition.
                    The integrity digest is 0 by default. Software must write a non-zero
                    digest value via the direct access interface in order to lock the partition.
                    After a reset, write access to the OWNER_SW_CFG partition is locked and
                    the digest becomes visible in this CSR.
                    ''',
          count:     "NumDigestWords",
          swaccess:  "ro",
          hwaccess:  "hwo",
          hwext:     "true",
          cname:     "WORD",
          resval:    0,
          tags: [ // OTP internal HW will update status so can not auto-predict its value.
                  "excl:CsrAllTests:CsrExclCheck"],
          fields: [
            { bits: "31:0"
            }
          ]
        }
      },
      { multireg: {
          name:     "ROT_CREATOR_AUTH_CODESIGN_DIGEST",
          desc:     '''
                    Integrity digest for the ROT_CREATOR_AUTH_CODESIGN partition.
                    The integrity digest is 0 by default. Software must write a non-zero
                    digest value via the direct access interface in order to lock the partition.
                    After a reset, write access to the ROT_CREATOR_AUTH_CODESIGN partition is locked and
                    the digest becomes visible in this CSR.
                    ''',
          count:     "NumDigestWords",
          swaccess:  "ro",
          hwaccess:  "hwo",
          hwext:     "true",
          cname:     "WORD",
          resval:    0,
          tags: [ // OTP internal HW will update status so can not auto-predict its value.
                  "excl:CsrAllTests:CsrExclCheck"],
          fields: [
            { bits: "31:0"
            }
          ]
        }
      },
      { multireg: {
          name:     "ROT_CREATOR_AUTH_STATE_DIGEST",
          desc:     '''
                    Integrity digest for the ROT_CREATOR_AUTH_STATE partition.
                    The integrity digest is 0 by default. Software must write a non-zero
                    digest value via the direct access interface in order to lock the partition.
                    After a reset, write access to the ROT_CREATOR_AUTH_STATE partition is locked and
                    the digest becomes visible in this CSR.
                    ''',
          count:     "NumDigestWords",
          swaccess:  "ro",
          hwaccess:  "hwo",
          hwext:     "true",
          cname:     "WORD",
          resval:    0,
          tags: [ // OTP internal HW will update status so can not auto-predict its value.
                  "excl:CsrAllTests:CsrExclCheck"],
          fields: [
            { bits: "31:0"
            }
          ]
        }
      },
      { multireg: {
          name:     "HW_CFG0_DIGEST",
          desc:     '''
                    Integrity digest for the HW_CFG0 partition.
                    The integrity digest is 0 by default. The digest calculation can be triggered via the !!DIRECT_ACCESS_CMD.
                    After a reset, the digest then becomes visible in this CSR, and the corresponding partition becomes write-locked.
                    ''',
          count:     "NumDigestWords",
          swaccess:  "ro",
          hwaccess:  "hwo",
          hwext:     "true",
          cname:     "WORD",
          resval:    0,
          tags: [ // OTP internal HW will update status so can not auto-predict its value.
                  "excl:CsrAllTests:CsrExclCheck"],
          fields: [
            { bits: "31:0"
            }
          ]
        }
      },
      { multireg: {
          name:     "HW_CFG1_DIGEST",
          desc:     '''
                    Integrity digest for the HW_CFG1 partition.
                    The integrity digest is 0 by default. The digest calculation can be triggered via the !!DIRECT_ACCESS_CMD.
                    After a reset, the digest then becomes visible in this CSR, and the corresponding partition becomes write-locked.
                    ''',
          count:     "NumDigestWords",
          swaccess:  "ro",
          hwaccess:  "hwo",
          hwext:     "true",
          cname:     "WORD",
          resval:    0,
          tags: [ // OTP internal HW will update status so can not auto-predict its value.
                  "excl:CsrAllTests:CsrExclCheck"],
          fields: [
            { bits: "31:0"
            }
          ]
        }
      },
      { multireg: {
          name:     "SECRET0_DIGEST",
          desc:     '''
                    Integrity digest for the SECRET0 partition.
                    The integrity digest is 0 by default. The digest calculation can be triggered via the !!DIRECT_ACCESS_CMD.
                    After a reset, the digest then becomes visible in this CSR, and the corresponding partition becomes write-locked.
                    ''',
          count:     "NumDigestWords",
          swaccess:  "ro",
          hwaccess:  "hwo",
          hwext:     "true",
          cname:     "WORD",
          resval:    0,
          tags: [ // OTP internal HW will update status so can not auto-predict its value.
                  "excl:CsrAllTests:CsrExclCheck"],
          fields: [
            { bits: "31:0"
            }
          ]
        }
      },
      { multireg: {
          name:     "SECRET1_DIGEST",
          desc:     '''
                    Integrity digest for the SECRET1 partition.
                    The integrity digest is 0 by default. The digest calculation can be triggered via the !!DIRECT_ACCESS_CMD.
                    After a reset, the digest then becomes visible in this CSR, and the corresponding partition becomes write-locked.
                    ''',
          count:     "NumDigestWords",
          swaccess:  "ro",
          hwaccess:  "hwo",
          hwext:     "true",
          cname:     "WORD",
          resval:    0,
          tags: [ // OTP internal HW will update status so can not auto-predict its value.
                  "excl:CsrAllTests:CsrExclCheck"],
          fields: [
            { bits: "31:0"
            }
          ]
        }
      },
      { multireg: {
          name:     "SECRET2_DIGEST",
          desc:     '''
                    Integrity digest for the SECRET2 partition.
                    The integrity digest is 0 by default. The digest calculation can be triggered via the !!DIRECT_ACCESS_CMD.
                    After a reset, the digest then becomes visible in this CSR, and the corresponding partition becomes write-locked.
                    ''',
          count:     "NumDigestWords",
          swaccess:  "ro",
          hwaccess:  "hwo",
          hwext:     "true",
          cname:     "WORD",
          resval:    0,
          tags: [ // OTP internal HW will update status so can not auto-predict its value.
                  "excl:CsrAllTests:CsrExclCheck"],
          fields: [
            { bits: "31:0"
            }
          ]
        }
      },
      { multireg: {
          name:     "SECRET3_DIGEST",
          desc:     '''
                    Integrity digest for the SECRET3 partition.
                    The integrity digest is 0 by default. The digest calculation can be triggered via the !!DIRECT_ACCESS_CMD.
                    After a reset, the digest then becomes visible in this CSR, and the corresponding partition becomes write-locked.
                    ''',
          count:     "NumDigestWords",
          swaccess:  "ro",
          hwaccess:  "hwo",
          hwext:     "true",
          cname:     "WORD",
          resval:    0,
          tags: [ // OTP internal HW will update status so can not auto-predict its value.
                  "excl:CsrAllTests:CsrExclCheck"],
          fields: [
            { bits: "31:0"
            }
          ]
        }
      },

      ////////////////////////////////
      // Software Config Partitions //
      ////////////////////////////////
      { skipto: "0x1000" }

      { window: {
          name: "SW_CFG_WINDOW"
          items: "NumSwCfgWindowWords"
          swaccess: "ro",
          desc: '''
          Any read to this window directly maps to the corresponding offset in the creator and owner software
          config partitions, and triggers an OTP readout of the bytes requested. Note that the transaction
          will block until OTP readout has completed.
          '''
        }
      }
    ],
  }
}
